simulator lang=spectre

library vlsi35

section tt
parameters toxn=7.5e-9
parameters toxp=7.7e-9
parameters toxe=7.5e-09
parameters dxl=0
parameters dxw=0
parameters dvtn=0
parameters dvtp=0
parameters delvtoe=0
parameters cjn=9.50957e-4
parameters cjp=1.38871e-3
parameters cje=0.00101893
parameters cjswn=2.84489e-10
parameters cjswp=3.86159e-10
parameters cjswe=3.057956e-10
parameters cgon=2.063e-10
parameters cgop=1.83e-10
parameters cgoe=1.96000e-10
parameters cjswgn=1.816514e-10
parameters cjswgp=4.415421e-11
parameters cjswge=1.524314e-10
parameters hdifn=3.65e-07
parameters hdifp=3.65e-07
parameters hdife=1.08e-06
include "vlsi35.scs" section=mos
endsection tt
//  ************** CORNER_LIB OF  SNSP   MODEL ****************************
section ss
parameters toxn=8.0e-9
parameters toxp=8.2e-9
parameters toxe=8e-09
parameters dxl=4e-8
parameters dxw=-6e-8
parameters dvtn=0.1
parameters dvtp=-0.1
parameters delvtoe=0.1
parameters cjn=1.0460527e-3
parameters cjp=1.527581e-3
parameters cje=0.001120823
parameters cjswn=3.129379e-10
parameters cjswp=4.247749e-10
parameters cjswe=3.363752e-10
parameters cgon=2.2693e-10
parameters cgop=2.013e-10
parameters cgoe=2.156e-10
parameters cjswgn=1.9981654e-10
parameters cjswgp=4.8569631e-11
parameters cjswge=1.676745e-10
parameters hdifn=3.65e-07
parameters hdifp=3.65e-07
parameters hdife=1.08e-06
include "vlsi35.scs" section=mos
endsection ss
//  ************** CORNER_LIB OF  FNFP   MODEL ****************************
section ff
parameters toxn=7.0e-9
parameters toxp=7.2e-9
parameters toxe=7e-09
parameters dxl=-4e-8
parameters dxw=6e-8
parameters dvtn=-0.1
parameters dvtp=0.1
parameters delvtoe=-0.1
parameters cjn=8.558613e-4
parameters cjp=1.249839e-3
parameters cje=0.000917037
parameters cjswn=2.560401e-10
parameters cjswp=3.475431e-10
parameters cjswe=2.75216e-10
parameters cgon=1.8567e-10
parameters cgop=1.647e-10
parameters cgoe=1.764e-10
parameters cjswgn=1.6348626e-10
parameters cjswgp=3.9738739e-11
parameters cjswge=1.371883e-10
parameters hdifn=3.65e-07
parameters hdifp=3.65e-07
parameters hdife=1.08e-06
include "vlsi35.scs" section=mos
endsection ff
//  ************** CORNER_LIB OF  SNFP   MODEL ****************************
section sf
parameters toxn=7.5e-9
parameters toxp=7.7e-9
parameters toxe=7.5e-09
parameters dxl=0
parameters dxw=0
parameters dvtn=0.1
parameters dvtp=0.1
parameters delvtoe=0.1
parameters cjn=1.0460527e-3
parameters cjp=1.249839e-3
parameters cje=0.001120823
parameters cjswn=3.129379e-10
parameters cjswp=3.475431e-10
parameters cjswe=3.363752e-10
parameters cgon=2.063e-10
parameters cgop=1.83e-10
parameters cgoe=1.96000e-10
parameters cjswgn=1.9981654e-10
parameters cjswgp=3.9738739e-11
parameters cjswge=1.676745e-10
parameters hdifn=3.65e-07
parameters hdifp=3.65e-07
parameters hdife=1.08e-06
include "vlsi35.scs" section=mos
endsection sf
//  ************** CORNER_LIB OF  FNSP   MODEL ****************************
section fs
parameters toxn=7.5e-9
parameters toxp=7.7e-9
parameters toxe=7.5e-09
parameters dxl=0
parameters dxw=0
parameters dvtn=-0.1
parameters dvtp=-0.1
parameters delvtoe=-0.1
parameters cjn=8.558613e-4
parameters cjp=1.527581e-3
parameters cje=0.000917037
parameters cjswn=2.560401e-10
parameters cjswp=4.247749e-10
parameters cjswe=2.75216e-10
parameters cgon=2.063e-10
parameters cgop=1.83e-10
parameters cgoe=1.96000e-10
parameters cjswgn=1.6348626e-10
parameters cjswgp=4.8569631e-11
parameters cjswge=1.371883e-10
parameters hdifn=3.65e-07
parameters hdifp=3.65e-07
parameters hdife=1.08e-06
include "vlsi35.scs" section=mos
endsection fs
//
//  *************************************************************
//                                                              *
//                   5V NORMAL DEVICES LIB                      *
//                                                              *
//  *************************************************************
//  *************** CORNER_LIB OF TYPICAL MODEL ****************************
section tt_5v
parameters toxn5=1.46e-8
parameters toxp5=1.48e-8
parameters toxe5=1.46e-08
parameters dxl5=0
parameters dxw5=0
parameters dvtn5=0
parameters dvtp5=0
parameters dvte5=0
parameters cjn5=9.97124e-4
parameters cjp5=1.385012e-3
parameters cje5=8.250009e-4
parameters cjswn5=2.68215e-10
parameters cjswp5=3.68278e-10
parameters cjswe5=6.894958e-10
parameters cgon5=1.6463e-10
parameters cgop5=1.714154e-10
parameters cgoe5=2.74000e-10
parameters cjswgn5=1.844056e-10
parameters cjswgp5=6.89655e-11
parameters cjswge5=5.323704e-10
parameters hdifn5=3.65e-07
parameters hdifp5=3.65e-07
parameters hdife5=3.8e-07
include "vlsi35.scs" section=mos_5v
endsection tt_5v
//  ************** CORNER_LIB OF  SNSP   MODEL ****************************
section ss_5v
parameters toxn5=1.56e-8
parameters toxp5=1.58e-8
parameters toxe5=1.56e-08
parameters dxl5=4e-8
parameters dxw5=-6e-8
parameters dvtn5=0.1
parameters dvtp5=-0.15
parameters dvte5=0.1
parameters cjn5=1.0968e-3
parameters cjp5=1.5235132e-3
parameters cje5=9.075010e-4
parameters cjswn5=2.950365e-10
parameters cjswp5=4.051058e-10
parameters cjswe5=7.584454e-10
parameters cgon5=1.811e-10
parameters cgop5=1.8855694e-10
parameters cgoe5=3.014000e-10
parameters cjswgn5=2.0284616e-10
parameters cjswgp5=7.586205e-11
parameters cjswge5=5.856075e-10
parameters hdifn5=3.65e-07
parameters hdifp5=3.65e-07
parameters hdife5=3.8e-7
include "vlsi35.scs" section=mos_5v
endsection ss_5v
//  ************** CORNER_LIB OF  FNFP   MODEL ****************************
section ff_5v
parameters toxn5=1.36e-8
parameters toxp5=1.38e-8
parameters toxe5=1.36e-8
parameters dxl5=-4e-8
parameters dxw5=6e-8
parameters dvtn5=-0.1
parameters dvtp5=0.15
parameters dvte5=-0.1
parameters cjn5=8.974116e-4
parameters cjp5=1.2465108e-3
parameters cje5=7.425008e-4
parameters cjswn5=2.413539e-10
parameters cjswp5=3.314502e-10
parameters cjswe5=6.205462e-10
parameters cgon5=1.48167e-10
parameters cgop5=1.5427386e-10
parameters cgoe5=2.466000e-10
parameters cjswgn5=1.65965e-10
parameters cjswgp5=6.206895e-11
parameters cjswge5=4.791334e-10
parameters hdifn5=3.65e-07
parameters hdifp5=3.65e-07
parameters hdife5=3.8e-7
include "vlsi35.scs" section=mos_5v
endsection ff_5v
//  ************** CORNER_LIB OF  SNFP   MODEL ****************************
section sf_5v
parameters toxn5=1.46e-8
parameters toxp5=1.48e-8
parameters toxe5=1.46e-8
parameters dxl5=0
parameters dxw5=0
parameters dvtn5=0.1
parameters dvtp5=0.15
parameters dvte5=0.1
parameters cjn5=1.0968e-3
parameters cjp5=1.2465108e-3
parameters cje5=9.075010e-4
parameters cjswn5=2.950365e-10
parameters cjswp5=3.314502e-10
parameters cjswe5=7.584454e-10
parameters cgon5=1.6463e-10
parameters cgop5=1.714154e-10
parameters cgoe5=2.7400e-10
parameters cjswgn5=2.0284616e-10
parameters cjswgp5=6.206895e-11
parameters cjswge5=5.856075e-10
parameters hdifn5=3.65e-07
parameters hdifp5=3.65e-07
parameters hdife5=3.8e-7
include "vlsi35.scs" section=mos_5v
endsection sf_5v
//  ************** CORNER_LIB OF  FNSP   MODEL ****************************
section fs_5v
parameters toxn5=1.46e-8
parameters toxp5=1.48e-8
parameters toxe5=1.46e-8
parameters dxl5=0
parameters dxw5=0
parameters dvtn5=-0.1
parameters dvtp5=-0.15
parameters dvte5=-0.1
parameters cjn5=8.974116e-4
parameters cjp5=1.5235132e-3
parameters cje5=7.425008e-4
parameters cjswn5=2.413539e-10
parameters cjswp5=4.051058e-10
parameters cjswe5=6.205462e-10
parameters cgon5=1.6463e-10
parameters cgop5=1.714154e-10
parameters cgoe5=2.7400e-10
parameters cjswgn5=1.65965e-10
parameters cjswgp5=7.586205e-11
parameters cjswge5=4.791334e-10
parameters hdifn5=3.65e-07
parameters hdifp5=3.65e-07
parameters hdife5=3.8e-7
include "vlsi35.scs" section=mos_5v
endsection fs_5v
//
//  ************************************************************************
//
//  *************************************************************
//                                                              *
//                                                              *
//                3.3V NORMAL DEVICES MODEL                     *
//                                                              *
//                                                              *
//                                                              *
//  *************************************************************
//
section mos
//
//  *************************************************************
//                                                              *
//                3.3V NMOS DEVICES MODEL                       *
//                                                              *
//  *************************************************************
model nch bsim3v3  {
     1: type=n minr=1e-60 lmin=1.207e-06 - dxl lmax=2.01e-05 wmin=1.183e-06 - dxw wmax=1.9983e-5
+ - dxw tnom=25 version=3.1 ldif=1.2e-07 hdif=hdifn rsh=82.2 rd=0 rs=0 tox=toxn
+ xj=1e-07 nch=2.3579e+17 lln=1 lwn=1 wln=1 wwn=1 lint=4e-08 ll=0 lw=0 lwl=0 wint=4e-08
+ wl=0 ww=0 wwl=0 mobmod=1 binunit=2 xl=3e-08 + dxl xw=1.5e-07 + dxw dwg=0 dwb=0
+ vth0=dvtn + 0.536027 lvth0=3.726466e-08 wvth0=-2.1316e-08 pvth0=-2.460013e-14
+ k1=0.5246611 lk1=-1.639613e-08 wk1=-5.031044e-08 pk1=2.211867e-14 k2=0.02709882
+ lk2=-6.586022e-09 wk2=5.785586e-09 pk2=3.435911e-15 k3=0 dvt0=0 dvt1=0 dvt2=0
+ dvt0w=0 dvt1w=0 dvt2w=0 nlx=0 w0=0 k3b=0 vsat=95850.88 lvsat=0.01310061 wvsat=0.0008223997
+ pvsat=-1.641506e-08 ua=3.196265e-11 lua=-3.698079e-17 wua=-6.408507e-16 pua=7.414642e-22
+ ub=2.045354e-18 lub=6.227287e-25 wub=5.533028e-26 pub=-1.805726e-30 uc=6.725734e-11
+ luc=1.901776e-17 wuc=-3.996494e-17 puc=-3.876839e-23 rdsw=750 prwb=0 prwg=0 wr=1
+ u0=0.04660162 lu0=5.515446e-09 wu0=-1.626703e-08 pu0=-4.134264e-15 a0=0.5017616
+ la0=5.552729e-07 wa0=6.615518e-07 pa0=-5.219843e-13 keta=-0.008348037 lketa=2.403177e-08
+ wketa=2.44925e-08 pketa=-3.102829e-14 a1=0 a2=0.99 ags=0.09736285 lags=1.223815e-07
+ wags=1.607973e-07 pags=-4.561918e-14 b0=0 b1=0 voff=-0.1432202 lvoff=3.766451e-08
+ wvoff=2.755289e-08 pvoff=-1.641511e-14 nfactor=1.071551 lnfactor=-3.18949e-07
+ wnfactor=-3.166332e-07 pnfactor=4.241266e-13 cit=-7.628655e-05 lcit=2.723331e-10
+ wcit=4.660042e-10 pcit=-4.03804e-16 cdsc=0 cdscb=0 cdscd=0 eta0=0.0002181413 leta0=4.893156e-10
+ weta0=-2.201543e-10 peta0=3.379313e-16 etab=1.65427e-05 letab=-1.913991e-11 wetab=-2.072801e-11
+ petab=2.39823e-17 dsub=0 pclm=0.1632291 lpclm=7.33948e-07 wpclm=7.523777e-09 ppclm=-1.501737e-13
+ pdiblc1=1e-05 pdiblc2=-0.0001189527 lpdiblc2=3.04769e-09 wpdiblc2=7.281391e-12
+ ppdiblc2=-5.988417e-16 pdiblcb=0.138753 drout=0 pscbe1=4.710076e+08 lpscbe1=-47.68667
+ wpscbe1=-72.788 ppscbe1=-1.725277e-05 pscbe2=0.0001510638 lpscbe2=-1.69574e-10
+ wpscbe2=-1.390941e-10 ppscbe2=1.578688e-16 pvag=0 delta=0.01 alpha0=2.5e-06 beta0=20.7
+ kt1=-0.2700492 lkt1=-3.095004e-08 wkt1=2.812907e-08 pkt1=7.879249e-14 kt2=-0.04153765
+ lkt2=2.524311e-08 wkt2=2.833375e-08 pkt2=-1.608147e-14 at=2219.528 lat=-0.02686487
+ wat=-0.002395568 pat=2.596705e-08 ute=-2.065168 lute=-4.132515e-07 wute=4.668071e-07
+ pute=3.33133e-13 ua1=1.422613e-10 lua1=-1.44336e-15 wua1=9.693937e-16 pua1=1.598886e-22
+ ub1=-2.172033e-18 lub1=1.404262e-24 wub1=5.546184e-26 pub1=6.856764e-31 uc1=-5.716306e-11
+ luc1=5.31648e-17 wuc1=-2.396283e-17 puc1=-2.142338e-24 kt1l=0 prt=24.11496 lprt=-1.086812e-05
+ wprt=-0.000500091 pprt=1.361775e-11 cj=cjn cjsw=cjswn cjswg=cjswgn mj=0.3297355
+ mjsw=0.1303453 mjswg=0.1303453 pb=0.6944804 pbsw=0.6944804 pbswg=0.6944804 cta=9.42521e-4
+ ctp=4.91382e-04 pta=1.485657e-03 ptp=1.485657e-03 cgdo=cgon cgso=cgon xti=3 n=1
+ capmod=0 nqsmod=0 xpart=1 cf=0
+ js=6.27496e-05 jsw=5.79847e-10
//
//
     2: type=n minr=1e-60 lmin=8.07e-07 - dxl lmax=1.207e-06 - dxl wmin=1.183e-06 - dxw wmax=1.9983e-5
+ - dxw tnom=25 version=3.1 ldif=1.2e-07 hdif=hdifn rsh=82.2 rd=0 rs=0 tox=toxn
+ xj=1e-07 nch=2.3579e+17 lln=1 lwn=1 wln=1 wwn=1 lint=4e-08 ll=0 lw=0 lwl=0 wint=4e-08
+ wl=0 ww=0 wwl=0 mobmod=1 binunit=2 xl=3e-08 + dxl xw=1.5e-07 + dxw dwg=0 dwb=0
+ vth0=dvtn + 0.546655 lvth0=2.496758e-08 wvth0=-4.998887e-08 pvth0=8.574382e-15
+ k1=0.4989724 lk1=1.332564e-08 wk1=-1.063668e-07 pk1=8.697584e-14 k2=0.02537151
+ lk2=-4.587532e-09 wk2=1.546677e-08 pk2=-7.765214e-15 k3=0 dvt0=0 dvt1=0 dvt2=0
+ dvt0w=0 dvt1w=0 dvt2w=0 nlx=0 w0=0 k3b=0 vsat=129157.8 lvsat=-0.02543551 wvsat=-0.07469934
+ pvsat=7.096359e-08 ua=0 ub=3.817944e-18 lub=-1.428159e-24 wub=-3.001886e-24 pub=1.731473e-30
+ uc=1.288592e-10 luc=-5.225554e-17 wuc=-1.385508e-16 puc=7.529545e-23 rdsw=750
+ prwb=0 prwg=0 wr=1 u0=0.05813805 lu0=-7.83221e-09 wu0=-2.807534e-08 pu0=9.527953e-15
+ a0=1.417374 la0=-5.040912e-07 wa0=4.499891e-07 pa0=-2.772062e-13 keta=0.02457614
+ lketa=-1.40615e-08 wketa=-1.016334e-08 pketa=9.068513e-15 a1=0 a2=0.99 ags=0.5850528
+ lags=-4.418758e-07 wags=4.016458e-07 pags=-3.242809e-13 b0=0 b1=0 voff=-0.1838075
+ lvoff=8.462402e-08 wvoff=1.050108e-07 pvoff=-1.060339e-13 nfactor=-0.0335216 lnfactor=9.596193e-07
+ wnfactor=1.057246e-06 pnfactor=-1.165451e-12 cit=0.0004911736 lcit=-3.842184e-10
+ wcit=-3.289006e-10 pcit=5.159007e-16 cdsc=0 cdscb=0 cdscd=0 eta0=0.0001221602
+ leta0=6.003658e-10 weta0=9.98899e-10 peta0=-1.072513e-15 etab=-6.307671e-06 letab=7.29797e-12
+ wetab=1.264687e-10 petab=-1.463242e-16 dsub=0 pclm=0.7657633 lpclm=3.681587e-08
+ wpclm=-3.195318e-07 ppclm=2.282295e-13 pdiblc1=1e-05 pdiblc2=-0.001092725 lpdiblc2=4.174345e-09
+ wpdiblc2=-5.786619e-10 ppdiblc2=7.909472e-17 pdiblcb=-0.1138522 lpdiblcb=2.922645e-07
+ wpdiblcb=3.165146e-07 ppdiblcb=-3.662074e-13 drout=0 pscbe1=4.682528e+08 lpscbe1=-44.49948
+ wpscbe1=-209.8855 ppscbe1=0.0001413691 pscbe2=3.714287e-06 lpscbe2=9.093489e-13
+ wpscbe2=-8.065528e-13 ppscbe2=-2.129907e-18 pvag=0 delta=0.01 alpha0=2.5e-06 beta0=20.7
+ kt1=-0.2160808 lkt1=-9.339147e-08 wkt1=3.355112e-08 pkt1=7.251917e-14 kt2=-0.01143072
+ lkt2=-9.590603e-09 wkt2=2.278139e-08 pkt2=-9.657396e-15 at=-66481.34 lat=0.05262202
+ wat=0.09716874 pat=-8.922884e-08 ute=-2.188333 lute=-2.707498e-07 wute=5.839889e-08
+ pute=8.056612e-13 ua1=4.797778e-10 lua1=-1.833867e-15 wua1=-9.438131e-16 pua1=2.373469e-21
+ ub1=-3.79573e-18 lub1=3.282878e-24 wub1=4.301764e-24 pub1=-4.227295e-30 uc1=-3.774725e-11
+ luc1=3.07007e-17 wuc1=3.189914e-17 puc1=-6.677463e-23 kt1l=0 prt=46.58106 lprt=-3.686147e-05
+ wprt=-0.001359025 pprt=1.007405e-09 cj=cjn cjsw=cjswn cjswg=cjswgn mj=0.3297355
+ mjsw=0.1303453 mjswg=0.1303453 pb=0.6944804 pbsw=0.6944804 pbswg=0.6944804 cta=9.42521e-4
+ ctp=4.91382e-04 pta=1.485657e-03 ptp=1.485657e-03 cgdo=cgon cgso=cgon xti=3 n=1
+ capmod=0 nqsmod=0 xpart=1 cf=0
+ js=6.27496e-05 jsw=5.79847e-10
//
//
     3: type=n minr=1e-60 lmin=3.5e-07 lmax=8.07e-07 - dxl wmin=1.183e-06 - dxw wmax=1.9983e-5
+ - dxw tnom=25 version=3.1 ldif=1.2e-07 hdif=hdifn rsh=82.2 rd=0 rs=0 tox=toxn
+ xj=1e-07 nch=2.3579e+17 lln=1 lwn=1 wln=1 wwn=1 lint=4e-08 ll=0 lw=0 lwl=0 wint=4e-08
+ wl=0 ww=0 wwl=0 mobmod=1 binunit=2 xl=3e-08 + dxl xw=1.5e-07 + dxw dwg=0 dwb=0
+ vth0=dvtn + 0.582913 lvth0=-2.479376e-09 wvth0=-6.03258e-08 pvth0=1.639944e-14
+ k1=0.4858325 lk1=2.327254e-08 wk1=6.104411e-08 pk1=-3.97542e-14 k2=0.04534535
+ lk2=-1.970772e-08 wk2=-1.945053e-09 pk2=5.415533e-15 k3=0 dvt0=0 dvt1=0 dvt2=0
+ dvt0w=0 dvt1w=0 dvt2w=0 nlx=0 w0=0 k3b=0 vsat=95126.3 lvsat=0.0003263514 wvsat=0.0276876
+ pvsat=-6.543329e-09 ua=0 ub=2.104607e-18 lub=-1.31162e-25 wub=-5.904336e-25 pub=-9.399655e-32
+ uc=6.617273e-11 luc=-4.801916e-18 wuc=-4.640422e-17 puc=5.540488e-24 rdsw=750
+ prwb=0 prwg=0 wr=1 u0=0.04861747 lu0=-6.251291e-10 wu0=-1.520027e-08 pu0=-2.184713e-16
+ a0=0.7344329 la0=1.289558e-08 wa0=-2.513495e-07 pa0=2.537071e-13 keta=0.01065971
+ lketa=-3.526753e-09 wketa=-3.419267e-08 pketa=2.725872e-14 a1=0 a2=0.99 ags=0.2223535
+ lags=-1.673124e-07 wags=-3.122171e-07 pags=2.161134e-13 b0=0 b1=0 voff=-0.0716667
+ lvoff=-2.66569e-10 wvoff=-6.081282e-08 pvoff=1.949458e-14 nfactor=1.373063 lnfactor=-1.051655e-07
+ wnfactor=-4.708978e-07 pnfactor=-8.646475e-15 cit=-9.014477e-05 lcit=5.583969e-11
+ wcit=2.859396e-10 pcit=5.046674e-17 cdsc=0 cdscb=0 cdscd=0 eta0=-0.0003508224
+ leta0=9.584137e-10 weta0=-1.229799e-09 peta0=6.146112e-16 etab=0.001435363 letab=-1.084047e-09
+ wetab=-1.334921e-09 petab=9.599482e-16 dsub=0 pclm=0.7913016 lpclm=1.748337e-08
+ wpclm=-2.414444e-08 ppclm=4.621286e-15 pdiblc1=1e-05 pdiblc2=0.0001653532 lpdiblc2=3.22198e-09
+ wpdiblc2=-3.987821e-11 ppdiblc2=-3.287649e-16 pdiblcb=0.3624882 lpdiblcb=-6.83252e-08
+ wpdiblcb=-1.827158e-07 ppdiblcb=1.171009e-14 drout=0 pscbe1=3.496792e+08 lpscbe1=45.26074
+ wpscbe1=-43.00555 ppscbe1=1.504091e-05 pscbe2=4.060865e-06 lpscbe2=6.469898e-13
+ wpscbe2=-5.382114e-12 ppscbe2=1.333792e-18 pvag=0 delta=0.01 alpha0=2.5e-06 beta0=20.7
+ kt1=-0.4001584 lkt1=4.595524e-08 wkt1=2.659199e-07 pkt1=-1.03384e-13 kt2=-0.03018077
+ lkt2=4.603183e-09 wkt2=1.978027e-08 pkt2=-7.385543e-15 at=-1454.14 lat=0.003396435
+ wat=-0.01336298 pat=-5.556333e-09 ute=-2.743312 lute=1.493698e-07 wute=1.759122e-06
+ pute=-4.817859e-13 ua1=-2.551773e-09 lua1=4.610171e-16 wua1=5.268021e-15 pua1=-2.32889e-21
+ ub1=1.096567e-18 lub1=-4.205904e-25 wub1=-6.127881e-24 pub1=3.667946e-30 uc1=1.205581e-11
+ luc1=-7.000217e-18 wuc1=-1.569118e-16 puc1=7.615527e-23 kt1l=0 prt=0.2675717 lprt=-1.802119e-06
+ wprt=8.331496e-06 pprt=-2.768447e-11 cj=cjn cjsw=cjswn cjswg=cjswgn mj=0.3297355
+ mjsw=0.1303453 mjswg=0.1303453 pb=0.6944804 pbsw=0.6944804 pbswg=0.6944804 cta=9.42521e-4
+ ctp=4.91382e-04 pta=1.485657e-03 ptp=1.485657e-03 cgdo=cgon cgso=cgon xti=3 n=1
+ capmod=0 nqsmod=0 xpart=1 cf=0
+ js=6.27496e-05 jsw=5.79847e-10
//
//
     4: type=n minr=1e-60 lmin=1.207e-06 - dxl lmax=2.01e-05 wmin=7.83e-07 - dxw wmax=1.183e-06
+ - dxw tnom=25 version=3.1 ldif=1.2e-07 hdif=hdifn rsh=82.2 rd=0 rs=0 tox=toxn
+ xj=1e-07 nch=2.3579e+17 lln=1 lwn=1 wln=1 wwn=1 lint=4e-08 ll=0 lw=0 lwl=0 wint=4e-08
+ wl=0 ww=0 wwl=0 mobmod=1 binunit=2 xl=3e-08 + dxl xw=1.5e-07 + dxw dwg=0 dwb=0
+ vth0=dvtn + 0.528243 lvth0=1.080427e-08 wvth0=-1.156297e-08 pvth0=8.55473e-15
+ k1=0.4545522 lk1=3.322464e-08 wk1=3.753591e-08 pk1=-4.005616e-14 k2=0.02647978
+ lk2=7.992918e-09 wk2=6.561244e-09 pk2=-1.48315e-14 k3=0 dvt0=0 dvt1=0 dvt2=0 dvt0w=0
+ dvt1w=0 dvt2w=0 nlx=0 w0=0 k3b=0 vsat=96507.23 ua=-7.217974e-10 lua=8.351195e-16
+ wua=3.036106e-16 pua=-3.512775e-22 ub=2.902607e-18 lub=-1.401372e-24 wub=-1.018808e-24
+ pub=7.304723e-31 uc=7.178552e-11 luc=-2.088186e-17 wuc=-4.563875e-17 puc=1.122583e-23
+ rdsw=750 prwb=0 prwg=0 wr=1 u0=0.03723282 lu0=-2.798723e-09 wu0=-4.527918e-09
+ pu0=6.28339e-15 a0=1.848904 la0=-5.194055e-07 wa0=-1.026417e-06 pa0=8.245877e-13
+ keta=0.01166675 lketa=-2.805299e-09 wketa=-5.86025e-10 pketa=2.598561e-15 a1=0
+ a2=0.99 ags=0.7010739 lags=-4.640424e-07 wags=-5.956526e-07 pags=6.8917e-13 b0=0
+ b1=0 voff=-0.1212307 lvoff=2.456386e-08 nfactor=0.8705778 lnfactor=-1.828959e-08
+ wnfactor=-6.481431e-08 pnfactor=4.740038e-14 cit=0.0002549786 lcit=-4.391399e-11
+ wcit=5.092893e-11 pcit=-7.546486e-18 cdsc=0 cdscb=0 cdscd=0 eta0=-8.412339e-05
+ leta0=1.002234e-09 weta0=1.585833e-10 peta0=-3.047557e-16 etab=-3.010733e-05 letab=1.752946e-10
+ wetab=3.772446e-11 petab=-2.19644e-16 dsub=0 pclm=0.1692336 lpclm=6.140966e-07
+ pdiblc1=1e-05 pdiblc2=-0.000347682 lpdiblc2=1.437708e-09 wpdiblc2=2.938791e-10
+ ppdiblc2=1.418466e-15 pdiblcb=0.1387533 drout=0 pscbe1=3.519534e+08 lpscbe1=-125.1231
+ wpscbe1=76.38679 ppscbe1=7.977505e-05 pscbe2=-8.737216e-05 lpscbe2=9.863835e-11
+ wpscbe2=1.596661e-10 ppscbe2=-1.782013e-16 pvag=0 delta=0.01 alpha0=2.5e-06 beta0=20.7
+ kt1=-0.1499315 lkt1=-2.115566e-09 wkt1=-1.223785e-07 pkt1=4.266289e-14 kt2=-0.02087417
+ lkt2=5.041189e-08 wkt2=2.442399e-09 pkt2=-4.761794e-14 at=-21673.44 lat=0.006954652
+ wat=0.02754232 pat=-1.640881e-08 ute=-2.565965 lute=5.17659e-07 wute=1.094306e-06
+ pute=-8.332978e-13 ua1=-1.6811e-09 lua1=1.19284e-15 wua1=3.254065e-15 pua1=-3.143271e-21
+ ub1=-1.065109e-18 lub1=-2.464934e-25 wub1=-1.331515e-24 pub1=2.754072e-30 uc1=-8.220291e-11
+ luc1=-3.608129e-17 wuc1=7.412109e-18 puc1=1.09683e-22 kt1l=0 prt=-1223.895 lprt=0.0009821714
+ wprt=0.001063665 pprt=-1.230661e-09 cj=cjn cjsw=cjswn cjswg=cjswgn mj=0.3297355
+ mjsw=0.1303453 mjswg=0.1303453 pb=0.6944804 pbsw=0.6944804 pbswg=0.6944804 cta=9.42521e-4
+ ctp=4.91382e-04 pta=1.485657e-03 ptp=1.485657e-03 cgdo=cgon cgso=cgon xti=3 n=1
+ capmod=0 nqsmod=0 xpart=1 cf=0
+ js=6.27496e-05 jsw=5.79847e-10
//
//
     5: type=n minr=1e-60 lmin=8.07e-07 - dxl lmax=1.207e-06 - dxl wmin=7.83e-07 - dxw wmax=1.183e-06
+ - dxw tnom=25 version=3.1 ldif=1.2e-07 hdif=hdifn rsh=82.2 rd=0 rs=0 tox=toxn
+ xj=1e-07 nch=2.3579e+17 lln=1 lwn=1 wln=1 wwn=1 lint=4e-08 ll=0 lw=0 lwl=0 wint=4e-08
+ wl=0 ww=0 wwl=0 mobmod=1 binunit=2 xl=3e-08 + dxl xw=1.5e-07 + dxw dwg=0 dwb=0
+ vth0=dvtn + 0.467619 lvth0=8.094657e-08 wvth0=4.90438e-08 pvth0=-6.156729e-14
+ k1=0.358099 lk1=1.44821e-07 wk1=7.01475e-08 pk1=-7.778778e-14 k2=0.07054502 lk2=-4.299056e-08
+ wk2=-4.113562e-08 pk2=4.035377e-14 k3=0 dvt0=0 dvt1=0 dvt2=0 dvt0w=0 dvt1w=0 dvt2w=0
+ nlx=0 w0=0 k3b=0 vsat=78576.45 lvsat=0.02074592 wvsat=-0.01132088 pvsat=1.309826e-08
+ ua=0 ub=5.741077e-19 lub=1.292701e-24 wub=1.062641e-24 pub=-1.677764e-30 uc=3.660264e-11
+ luc=1.982473e-17 wuc=-2.295341e-17 puc=-1.502111e-23 rdsw=750 prwb=0 prwg=0 wr=1
+ u0=0.03874022 lu0=-4.542793e-09 wu0=-3.769856e-09 pu0=5.406313e-15 a0=2.791505
+ la0=-1.609995e-06 wa0=-1.271796e-06 pa0=1.108491e-12 keta=0.0321512 lketa=-2.65058e-08
+ wketa=-1.965488e-08 pketa=2.466123e-14 a1=0 a2=0.99 ags=0.9056002 lags=-7.006794e-07
+ b0=0 b1=0 voff=-0.1 nfactor=0.7543952 lnfactor=1.161336e-07 wnfactor=6.998602e-08
+ pnfactor=-1.085636e-13 cit=0.000285048 lcit=-7.870424e-11 wcit=-7.062511e-11 pcit=1.330915e-16
+ cdsc=0 cdscb=0 cdscd=0 eta0=0.003352228 leta0=-2.973624e-09 weta0=-3.048375e-09
+ peta0=3.405695e-15 etab=0.0006475641 letab=-6.087711e-10 wetab=-6.928325e-10 petab=6.256102e-16
+ dsub=0 pclm=1.032518 lpclm=-3.847236e-07 wpclm=-6.537757e-07 ppclm=7.564184e-13
+ pdiblc1=1e-05 pdiblc2=-0.00416775 lpdiblc2=5.857526e-09 wpdiblc2=3.274343e-09
+ ppdiblc2=-2.029931e-15 pdiblcb=0.1387533 drout=0 pscbe1=1.089719e+08 lpscbe1=156.0066
+ wpscbe1=240.2935 ppscbe1=-0.000109865 pscbe2=-5.255092e-06 lpscbe2=3.628897e-12
+ wpscbe2=1.043208e-11 ppscbe2=-5.537501e-18 pvag=0 delta=0.01 alpha0=2.5e-06 beta0=20.7
+ kt1=-0.09596287 lkt1=-6.455721e-08 wkt1=-1.169567e-07 pkt1=3.638983e-14 kt2=0.07813779
+ lkt2=-6.414494e-08 wkt2=-8.944794e-08 pkt2=5.869918e-14 at=-110972.9 lat=0.1102741
+ wat=0.1529166 pat=-1.614668e-07 ute=-3.559982 lute=1.667736e-06 wute=1.777075e-06
+ pute=-1.623261e-12 ua1=-5.651362e-10 lua1=-9.832879e-17 wua1=3.654639e-16 pua1=1.9884e-22
+ ub1=-6.47051e-19 lub1=-7.301864e-25 wub1=3.564699e-25 pub1=8.010748e-31 uc1=-8.009362e-12
+ luc1=-1.219232e-16 wuc1=-5.362414e-18 puc1=1.244631e-22 kt1l=0 prt=-2390.559 lprt=0.002332001
+ wprt=0.00169471 pprt=-1.960779e-09 cj=cjn cjsw=cjswn cjswg=cjswgn mj=0.3297355
+ mjsw=0.1303453 mjswg=0.1303453 pb=0.6944804 pbsw=0.6944804 pbswg=0.6944804 cta=9.42521e-4
+ ctp=4.91382e-04 pta=1.485657e-03 ptp=1.485657e-03 cgdo=cgon cgso=cgon xti=3 n=1
+ capmod=0 nqsmod=0 xpart=1 cf=0
+ js=6.27496e-05 jsw=5.79847e-10
//
//
     6: type=n minr=1e-60 lmin=3.5e-07 lmax=8.07e-07 - dxl wmin=7.83e-07 - dxw wmax=1.183e-06
+ - dxw tnom=25 version=3.1 ldif=1.2e-07 hdif=hdifn rsh=82.2 rd=0 rs=0 tox=toxn
+ xj=1e-07 nch=2.3579e+17 lln=1 lwn=1 wln=1 wwn=1 lint=4e-08 ll=0 lw=0 lwl=0 wint=4e-08
+ wl=0 ww=0 wwl=0 mobmod=1 binunit=2 xl=3e-08 + dxl xw=1.5e-07 + dxw dwg=0 dwb=0
+ vth0=dvtn + 0.574607 lvth0=-4.339362e-11 wvth0=-4.991848e-08 pvth0=1.334716e-14
+ k1=0.5850455 lk1=-2.697753e-08 wk1=-6.326979e-08 pk1=2.320913e-14 k2=0.03486114
+ lk2=-1.597786e-08 wk2=1.119166e-08 pk2=7.420165e-16 k3=0 dvt0=0 dvt1=0 dvt2=0
+ dvt0w=0 dvt1w=0 dvt2w=0 nlx=0 w0=0 k3b=0 vsat=119212.2 lvsat=-0.01001536 wvsat=-0.002492058
+ pvsat=6.414841e-09 ua=-1.425246e-09 lua=1.078912e-15 wua=1.785833e-15 pua=-1.351876e-21
+ ub=4.112102e-18 lub=-1.385562e-24 wub=-3.105826e-24 pub=1.477766e-30 uc=4.050535e-11
+ luc=1.687038e-17 wuc=-1.424299e-17 puc=-2.161491e-23 rdsw=750 prwb=0 prwg=0 wr=1
+ u0=0.02507698 lu0=5.800281e-09 wu0=1.429596e-08 pu0=-8.26951e-15 a0=0.3001916
+ la0=2.759296e-07 wa0=2.92755e-07 pa0=-7.587451e-14 keta=-0.05698659 lketa=4.097151e-08
+ wketa=5.056813e-08 pketa=-2.84976e-14 a1=0 a2=0.99 ags=-0.0458255 lags=1.954991e-08
+ wags=2.381111e-08 pags=-1.802502e-14 b0=0 b1=0 voff=-0.141804 lvoff=3.164562e-08
+ wvoff=2.706921e-08 pvoff=-2.049139e-14 nfactor=1.157475 lnfactor=-1.889977e-07
+ wnfactor=-2.007654e-07 pnfactor=9.63953e-14 cit=0.0001456854 lcit=2.679317e-11
+ wcit=-9.555716e-12 pcit=8.686202e-17 cdsc=0 cdscb=0 cdscd=0 eta0=-0.006824942
+ leta0=4.730496e-09 weta0=6.882274e-09 peta0=-4.111808e-15 etab=0.0002038415 letab=-2.728731e-10
+ wetab=2.081748e-10 petab=-5.645233e-17 dsub=0 pclm=0.8004329 lpclm=-2.090351e-07
+ wpclm=-3.558609e-08 ppclm=2.884489e-13 pdiblc1=1e-05 pdiblc2=0.005613619 lpdiblc2=-1.546974e-09
+ wpdiblc2=-6.866557e-09 ppdiblc2=5.646734e-15 pdiblcb=0.1320065 lpdiblcb=5.107366e-09
+ wpdiblcb=1.060778e-07 ppdiblcb=-8.030091e-14 drout=0 pscbe1=6.561562e+07 lpscbe1=188.8273
+ wpscbe1=312.9262 ppscbe1=-0.000164848 pscbe2=-1.060816e-05 lpscbe2=7.681177e-12
+ wpscbe2=1.299818e-11 ppscbe2=-7.480043e-18 pvag=0 delta=0.01 alpha0=2.5e-06 beta0=20.7
+ kt1=-0.2037678 lkt1=1.705115e-08 wkt1=1.984253e-08 pkt1=-6.716717e-14 kt2=-0.01380252
+ lkt2=5.453875e-09 wkt2=-7.416772e-10 pkt2=-8.45146e-15 at=92820.91 lat=-0.04399785
+ wat=-0.1314896 pat=5.382871e-08 ute=0.1429917 lute=-1.135416e-06 wute=-1.857417e-06
+ pute=1.12805e-12 ua1=7.997219e-09 lua1=-6.580034e-15 wua1=-7.949868e-15 pua1=6.493548e-21
+ ub1=-1.595098e-17 lub1=1.08549e-23 wub1=1.52327e-23 pub1=-1.046024e-29 uc1=-4.433896e-10
+ luc1=2.076597e-16 wuc1=4.137613e-16 puc1=-1.928136e-22 kt1l=0 prt=1397.411 lprt=-0.0005354923
+ wprt=-0.001742289 pprt=6.410293e-10 cj=cjn cjsw=cjswn cjswg=cjswgn mj=0.3297355
+ mjsw=0.1303453 mjswg=0.1303453 pb=0.6944804 pbsw=0.6944804 pbswg=0.6944804 cta=9.42521e-4
+ ctp=4.91382e-04 pta=1.485657e-03 ptp=1.485657e-03 cgdo=cgon cgso=cgon xti=3 n=1
+ capmod=0 nqsmod=0 xpart=1 cf=0
+ js=6.27496e-05 jsw=5.79847e-10
//
//
     7: type=n minr=1e-60 lmin=1.207e-06 - dxl lmax=2.01e-05 wmin=4e-07 wmax=7.83e-07 - dxw
+ tnom=25 version=3.1 ldif=1.2e-07 hdif=hdifn rsh=82.2 rd=0 rs=0 tox=toxn
+ xj=1e-07 nch=2.3579e+17 lln=1 lwn=1 wln=1 wwn=1 lint=4e-08 ll=0 lw=0 lwl=0 wint=4e-08
+ wl=0 ww=0 wwl=0 mobmod=1 binunit=2 xl=3e-08 + dxl xw=1.5e-07 + dxw dwg=0 dwb=0
+ vth0=dvtn + 0.544538 lvth0=1.720274e-08 wvth0=-2.546298e-08 pvth0=3.096841e-15
+ k1=0.5502741 lk1=-3.125255e-08 wk1=-4.411482e-08 pk1=1.494289e-14 k2=0.01727784
+ lk2=-1.487584e-08 wk2=1.441049e-08 pk2=4.675549e-15 k3=0 dvt0=0 dvt1=0 dvt2=0
+ dvt0w=0 dvt1w=0 dvt2w=0 nlx=0 w0=0 k3b=0 vsat=96507.23 ua=-7.802065e-10 lua=9.026988e-16
+ wua=3.534335e-16 pua=-4.089226e-22 ub=1.893473e-18 lub=-5.306664e-25 wub=-1.580168e-25
+ pub=-1.223976e-32 uc=2.085218e-11 luc=1.298873e-17 wuc=-2.192611e-18 puc=-1.766579e-23
+ rdsw=750 prwb=0 prwg=0 wr=1 u0=0.03104484 lu0=4.876105e-09 wu0=7.504263e-10 pu0=-2.632391e-16
+ a0=0.5611327 la0=5.492548e-07 wa0=7.205156e-08 pa0=-8.697965e-14 keta=0.01632805
+ lketa=1.817118e-09 wketa=-4.562111e-09 pketa=-1.344362e-15 a1=0 a2=0.99 ags=0.001377129
+ lags=3.717127e-07 wags=1.188842e-09 pags=-2.372926e-14 b0=0 b1=0 voff=-0.1332525
+ lvoff=3.847315e-08 wvoff=1.025464e-08 pvoff=-1.186462e-14 nfactor=1.473942 lnfactor=-7.516272e-07
+ wnfactor=-5.794843e-07 pnfactor=6.729374e-13 cit=-0.0006621464 lcit=1.027861e-09
+ wcit=8.332366e-10 pcit=-9.217706e-16 cdsc=0 cdscb=0 cdscd=0 eta0=7.131314e-05
+ leta0=5.99268e-10 weta0=2.599593e-11 peta0=3.897462e-17 etab=2.000076e-05 letab=-4.256616e-10
+ wetab=-5.017732e-12 petab=2.929716e-16 dsub=0 pclm=0.1762022 lpclm=4.750038e-07
+ wpclm=-5.944212e-09 ppclm=1.186463e-13 pdiblc1=1e-05 pdiblc2=0.0002290868 lpdiblc2=8.598363e-10
+ wpdiblc2=-1.981044e-10 ppdiblc2=1.91139e-15 pdiblcb=0.1304779 lpdiblcb=1.651774e-07
+ wpdiblcb=7.058936e-09 ppdiblcb=-1.408963e-13 drout=0 pscbe1=4.235152e+08 lpscbe1=-58.8318
+ wpscbe1=15.34459 ppscbe1=2.322858e-05 pscbe2=7.703648e-05 lpscbe2=-8.780832e-11
+ wpscbe2=1.942555e-11 ppscbe2=-1.916228e-17 pvag=0 delta=0.01 alpha0=2.5e-06 beta0=20.7
+ kt1=-0.3097948 lkt1=8.128185e-08 wkt1=1.398491e-08 pkt1=-2.847512e-14 kt2=-0.005076239
+ lkt2=-4.617562e-08 wkt2=-1.103323e-08 pkt2=3.477121e-14 at=82328.36 lat=-0.08739209
+ wat=-0.06117122 pat=6.406897e-08 ute=-1.349974 lute=-6.17695e-07 wute=5.706533e-08
+ pute=1.351592e-13 ua1=3.045211e-09 lua1=-4.130031e-15 wua1=-7.774787e-16 pua1=1.397139e-21
+ ub1=-3.662418e-18 lub1=4.251251e-24 wub1=8.839907e-25 pub1=-1.082504e-30 uc1=-1.046373e-10
+ luc1=1.031438e-16 wuc1=2.654866e-17 puc1=-9.075983e-24 kt1l=0 prt=473.8944 lprt=-0.0009821708
+ wprt=-0.0003845492 pprt=4.449234e-10 cj=cjn cjsw=cjswn cjswg=cjswgn mj=0.3297355
+ mjsw=0.1303453 mjswg=0.1303453 pb=0.6944804 pbsw=0.6944804 pbswg=0.6944804 cta=9.42521e-4
+ ctp=4.91382e-04 pta=1.485657e-03 ptp=1.485657e-03 cgdo=cgon cgso=cgon xti=3 n=1
+ capmod=0 nqsmod=0 xpart=1 cf=0
+ js=6.27496e-05 jsw=5.79847e-10
//
//
     8: type=n minr=1e-60 lmin=8.07e-07 - dxl lmax=1.207e-06 - dxl wmin=4e-07 wmax=7.83e-07
+ - dxw tnom=25 version=3.1 ldif=1.2e-07 hdif=hdifn rsh=82.2 rd=0 rs=0 tox=toxn
+ xj=1e-07 nch=2.3579e+17 lln=1 lwn=1 wln=1 wwn=1 lint=4e-08 ll=0 lw=0 lwl=0 wint=4e-08
+ wl=0 ww=0 wwl=0 mobmod=1 binunit=2 xl=3e-08 + dxl xw=1.5e-07 + dxw dwg=0 dwb=0
+ vth0=dvtn + 0.611238 lvth0=-5.996844e-08 wvth0=-7.346332e-08 pvth0=5.863323e-14
+ k1=0.4463096 lk1=8.903435e-08 wk1=-5.096067e-09 pk1=-3.02018e-14 k2=-0.009934468
+ lk2=1.660881e-08 wk2=2.751338e-08 pk2=-1.048449e-14 k3=0 dvt0=0 dvt1=0 dvt2=0
+ dvt0w=0 dvt1w=0 dvt2w=0 nlx=0 w0=0 k3b=0 vsat=51524.56 lvsat=0.05204498 wvsat=0.01175437
+ pvsat=-1.359984e-08 ua=0 ub=1.684949e-18 lub=-2.894038e-25 wub=1.150939e-25 pub=-3.282287e-31
+ uc=-5.621833e-11 luc=1.021593e-16 wuc=5.62229e-17 puc=-8.525252e-23 rdsw=750 prwb=0
+ prwg=0 wr=1 u0=0.03584241 lu0=-6.746811e-10 wu0=-1.298021e-09 pu0=2.106814e-15
+ a0=1.069539 la0=-3.897101e-08 wa0=1.970411e-07 pa0=-2.315925e-13 keta=0.01530131
+ lketa=3.005051e-09 wketa=-5.28193e-09 pketa=-5.115318e-16 a1=0 a2=0.99 ags=0.5853289
+ lags=-3.039196e-07 wags=2.731914e-07 pags=-3.384361e-13 b0=0 b1=0 voff=-0.1 nfactor=0.6173926
+ lnfactor=2.394008e-07 wnfactor=1.868493e-07 pnfactor=-2.137105e-13 cit=0.0003063107
+ lcit=-9.264402e-11 wcit=-8.876222e-11 pcit=1.449822e-16 cdsc=0 cdscb=0 cdscd=0
+ eta0=-0.0001093099 leta0=8.082487e-10 weta0=-9.568357e-11 peta0=1.797578e-16 etab=-0.001177763
+ letab=9.601505e-10 wetab=8.641713e-10 petab=-7.1268e-16 dsub=0 pclm=0.0900574
+ lpclm=5.746733e-07 wpclm=1.501435e-07 ppclm=-6.194717e-14 pdiblc1=1e-05 pdiblc2=-0.009213444
+ lpdiblc2=1.178484e-08 wpdiblc2=7.578321e-09 ppdiblc2=-7.085934e-15 pdiblcb=0.2732414
+ wpdiblcb=-1.147183e-07 drout=0 pscbe1=2.142517e+08 lpscbe1=183.286 wpscbe1=150.4898
+ ppscbe1=-0.0001331344 pscbe2=-3.838787e-06 lpscbe2=5.764359e-12 wpscbe2=9.223971e-12
+ ppscbe2=-7.359051e-18 pvag=0 delta=0.01 alpha0=2.5e-06 beta0=20.7 kt1=-0.1747238
+ lkt1=-7.499526e-08 wkt1=-4.977362e-08 pkt1=4.52935e-14 kt2=-0.09084979 lkt2=5.306439e-08
+ wkt2=5.469848e-08 pkt2=-4.128039e-14 at=156661.5 lat=-0.1733955 wat=-0.07537551
+ pat=8.050333e-08 ute=-1.664549 lute=-2.537307e-07 wute=1.602711e-07 pute=1.575007e-14
+ ua1=-1.327711e-09 lua1=9.29439e-16 wua1=1.01594e-15 pua1=-6.778459e-22 ub1=-4.245534e-19
+ lub1=5.05042e-25 wub1=1.666793e-25 pub1=-2.525749e-31 uc1=-1.090144e-10 luc1=1.082081e-16
+ wuc1=8.079491e-17 puc1=-7.183889e-23 kt1l=0 prt=404.2872 lprt=-0.0009016352 wprt=-0.0006892931
+ pprt=7.97512e-10 cj=cjn cjsw=cjswn cjswg=cjswgn mj=0.3297355 mjsw=0.1303453 mjswg=0.1303453
+ pb=0.6944804 pbsw=0.6944804 pbswg=0.6944804 cta=9.42521e-4 ctp=4.91382e-04 pta=1.485657e-03
+ ptp=1.485657e-03 cgdo=cgon cgso=cgon xti=3 n=1 capmod=0 nqsmod=0 xpart=1 cf=0
+ js=6.27496e-05 jsw=5.79847e-10
//
//
     9: type=n minr=1e-60 lmin=3.5e-07 lmax=8.07e-07 - dxl wmin=4e-07 wmax=7.83e-07 - dxw tnom=25
+ version=3.1 ldif=1.2e-07 hdif=hdifn rsh=82.2 rd=0 rs=0 tox=toxn xj=1e-07
+ nch=2.3579e+17 lln=1 lwn=1 wln=1 wwn=1 lint=4e-08 ll=0 lw=0 lwl=0 wint=4e-08 wl=0
+ ww=0 wwl=0 mobmod=1 binunit=2 xl=3e-08 + dxl xw=1.5e-07 + dxw dwg=0 dwb=0 vth0=dvtn
+ + 0.525422 lvth0=4.993819e-09 wvth0=-9.507126e-09 pvth0=1.021839e-14 k1=0.5813381
+ lk1=-1.318226e-08 wk1=-5.816663e-08 pk1=9.972617e-15 k2=0.02935361 lk2=-1.313227e-08
+ wk2=1.606665e-08 pk2=-1.819316e-15 k3=0 dvt0=0 dvt1=0 dvt2=0 dvt0w=0 dvt1w=0 dvt2w=0
+ nlx=0 w0=0 k3b=0 vsat=124715.3 lvsat=-0.003360439 wvsat=-0.005906745 pvsat=-2.303697e-10
+ ua=1.237881e-09 lua=-9.370761e-16 wua=-6.6957e-16 pua=5.068646e-22 ub=2.303303e-20
+ lub=9.686662e-25 wub=5.506454e-25 pub=-6.579411e-31 uc=9.352798e-11 luc=-1.119865e-17
+ wuc=-6.127926e-17 puc=3.696612e-24 rdsw=750 prwb=0 prwg=0 wr=1 u0=0.04878879 lu0=-1.047509e-08
+ wu0=-7.309575e-09 pu0=6.65756e-15 a0=0.2731722 la0=5.638784e-07 wa0=3.586827e-07
+ pa0=-3.539552e-13 keta=0.01651734 lketa=2.084521e-09 wketa=-1.463331e-08 pketa=6.567465e-15
+ a1=0 a2=0.99 ags=-0.09344225 lags=2.099102e-07 wags=9.137526e-08 pags=-2.008013e-13
+ b0=0 b1=0 voff=-0.1301078 lvoff=2.279158e-08 wvoff=1.628529e-08 pvoff=-1.232797e-14
+ nfactor=1.136485 lnfactor=-1.535521e-07 wnfactor=-1.784141e-07 pnfactor=6.279391e-14
+ cit=-9.737274e-05 lcit=2.129444e-10 wcit=2.148746e-10 pcit=-8.487093e-17 cdsc=0
+ cdscb=0 cdscd=0 eta0=0.0001017259 leta0=6.484946e-10 weta0=6.739802e-10 peta0=-4.028777e-16
+ etab=0.0005133018 letab=-3.199854e-10 wetab=-4.845151e-11 petab=-2.18245e-17 dsub=0
+ pclm=1.355904 lpclm=-3.835729e-07 wpclm=-5.100177e-07 ppclm=4.377949e-13 pdiblc1=1e-05
+ pdiblc2=0.002662655 lpdiblc2=2.794636e-09 wpdiblc2=-3.822584e-09 ppdiblc2=1.544552e-15
+ pdiblcb=0.5120286 lpdiblcb=-1.807619e-07 wpdiblcb=-2.286922e-07 ppdiblcb=8.627818e-14
+ drout=0 pscbe1=4.613509e+08 lpscbe1=-3.768093 wpscbe1=-35.53878 ppscbe1=7.689244e-06
+ pscbe2=4.618633e-06 lpscbe2=-6.379074e-13 wpscbe2=-5.490942e-13 ppscbe2=3.915955e-20
+ pvag=0 delta=0.01 alpha0=2.5e-06 beta0=20.7 kt1=-0.1251057 lkt1=-1.125561e-07
+ wkt1=-6.342647e-08 pkt1=5.562872e-14 kt2=-0.01401484 lkt2=-5.099672e-09 wkt2=-2.188774e-09
+ pkt2=1.783267e-15 at=-99596.23 lat=0.02059158 wat=0.0334882 pat=-1.906498e-09
+ ute=-2.786766 lute=5.957877e-07 wute=7.692041e-07 pute=-4.452122e-13 ua1=-2.983657e-09
+ lua1=2.182991e-15 wua1=2.243578e-15 pua1=-1.607168e-21 ub1=3.855079e-18 lub1=-2.73464e-24
+ wub1=-2.81326e-24 pub1=2.003239e-30 uc1=1.684049e-10 luc1=-1.017984e-16 wuc1=-1.267505e-16
+ puc1=8.527297e-23 kt1l=0 prt=-1377.407 lprt=0.0004471074 wprt=0.0006446759 pprt=-2.123025e-10
+ cj=cjn cjsw=cjswn cjswg=cjswgn mj=0.3297355 mjsw=0.1303453 mjswg=0.1303453 pb=0.6944804
+ pbsw=0.6944804 pbswg=0.6944804 cta=9.42521e-4 ctp=4.91382e-04 pta=1.485657e-03
+ ptp=1.485657e-03 cgdo=cgon cgso=cgon xti=3 n=1 capmod=0 nqsmod=0 xpart=1 cf=0
+ js=6.27496e-05 jsw=5.79847e-10
//
//
     10: type=n minr=1e-60 lmin=1.207e-06 - dxl lmax=2.01e-05 wmin=1.9983e-5 - dxw wmax=0.0002001
+ tnom=25 version=3.1 ldif=1.2e-07 hdif=hdifn rsh=82.2 rd=0 rs=0 tox=toxn
+ xj=1e-07 nch=2.3579e+17 lln=1 lwn=1 wln=1 wwn=1 lint=4e-08 ll=0 lw=0 lwl=0 wint=4e-08
+ wl=0 ww=0 wwl=0 mobmod=1 binunit=2 xl=3e-08 + dxl xw=1.5e-07 + dxw dwg=0 dwb=0
+ vth0=dvtn + 0.523596 lvth0=4.430968e-08 wvth0=2.279147e-07 pvth0=-1.658529e-13
+ k1=0.5035352 lk1=-1.691519e-08 wk1=3.732626e-07 pk1=3.252572e-14 k2=0.02639952
+ lk2=3.398003e-09 wk2=1.980659e-08 pk2=-1.967438e-13 k3=0 dvt0=0 dvt1=0 dvt2=0
+ dvt0w=0 dvt1w=0 dvt2w=0 nlx=0 w0=0 k3b=0 vsat=96575.78 lvsat=-0.001368327 wvsat=-0.01371178
+ pvsat=2.736871e-07 ua=-7.243246e-10 lua=8.380434e-16 wua=1.452271e-14 pua=-1.680277e-20
+ ub=2.507682e-18 lub=-9.292725e-25 wub=-9.214355e-24 pub=2.931189e-29 uc=4.653199e-11
+ luc=-2.983065e-18 wuc=3.755784e-16 puc=4.023481e-22 rdsw=750 prwb=0 prwg=0 wr=1
+ u0=0.03921134 lu0=6.986588e-09 wu0=1.319081e-07 pu0=-3.363066e-14 a0=0.5149775
+ la0=5.62179e-07 wa0=3.965712e-07 pa0=-6.604507e-13 keta=0.002816328 lketa=1.495658e-09
+ wketa=-1.99353e-07 pketa=4.208207e-13 a1=0 a2=0.99 ags=-0.0002663955 lags=1.790876e-07
+ wags=2.118263e-06 pags=-1.182575e-12 b0=0 b1=0 voff=-0.118934 lvoff=2.319556e-08
+ wvoff=-4.593862e-07 pvoff=2.736873e-13 nfactor=1.089919 lnfactor=9.594396e-08
+ wnfactor=-6.849148e-07 pnfactor=-7.894476e-12 cit=-0.0001081982 lcit=-1.689249e-10
+ wcit=1.105833e-09 pcit=8.443418e-15 cdsc=0 cdscb=0 cdscd=0 eta0=7.25065e-05 leta0=9.311983e-10
+ weta0=2.699823e-09 peta0=-8.521816e-15 etab=1.007015e-05 letab=-1.165116e-11 wetab=1.090467e-10
+ petab=-1.26167e-16 dsub=0 pclm=0.1835384 lpclm=3.285741e-07 wpclm=-3.996779e-07
+ ppclm=7.977571e-12 pdiblc1=1e-05 pdiblc2=0.0001413927 lpdiblc2=2.353788e-09 wpdiblc2=-5.212645e-09
+ ppdiblc2=1.331389e-14 pdiblcb=0.1387533 wpdiblcb=-7.049708e-12 ppdiblcb=8.156512e-18
+ drout=0 pscbe1=4.16586e+08 lpscbe1=95.76174 wpscbe1=1018.363 ppscbe1=-0.002893393
+ pscbe2=4.54933e-05 lpscbe2=-3.308092e-11 wpscbe2=1.977595e-09 ppscbe2=-2.578818e-15
+ pvag=0 delta=0.01 alpha0=2.5e-06 beta0=20.7 kt1=-0.2964827 lkt1=-3.814854e-09
+ wkt1=5.58119e-07 pkt1=-4.652679e-13 kt2=-0.02842824 lkt2=8.383796e-09 wkt2=-2.3451e-07
+ pkt2=3.219478e-13 at=58413.87 lat=-0.05857738 wat=-1.129092 pat=6.618029e-07 ute=-1.535532
+ lute=-2.949172e-07 wute=-1.015238e-05 pute=-2.039471e-12 ua1=2.097278e-09 lua1=-2.304323e-15
+ wua1=-3.822868e-14 pua1=1.742218e-20 ub1=-3.46834e-18 lub1=3.99078e-24 wub1=2.604641e-23
+ pub1=-5.117401e-29 uc1=-6.400205e-11 luc1=1.303836e-17 wuc1=1.13159e-16 puc1=8.023928e-22
+ kt1l=0 prt=-0.7466621 lprt=-6.926093e-06 wprt=-1.615575e-06 pprt=-6.542008e-11
+ cj=cjn cjsw=cjswn cjswg=cjswgn mj=0.3297355 mjsw=0.1303453 mjswg=0.1303453 pb=0.6944804
+ pbsw=0.6944804 pbswg=0.6944804 cta=9.42521e-4 ctp=4.91382e-04 pta=1.485657e-03
+ ptp=1.485657e-03 cgdo=cgon cgso=cgon xti=3 n=1 capmod=0 nqsmod=0 xpart=1 cf=0
+ js=6.27496e-05 jsw=5.79847e-10
//
//
     11: type=n minr=1e-60 lmin=8.07e-07 - dxl lmax=1.207e-06 - dxl wmin=1.9983e-5 - dxw wmax=0.0002001
+ tnom=25 version=3.1 ldif=1.2e-07 hdif=hdifn rsh=82.2 rd=0 rs=0 tox=toxn
+ xj=1e-07 nch=2.3579e+17 lln=1 lwn=1 wln=1 wwn=1 lint=4e-08 ll=0 lw=0 lwl=0 wint=4e-08
+ wl=0 ww=0 wwl=0 mobmod=1 binunit=2 xl=3e-08 + dxl xw=1.5e-07 + dxw dwg=0 dwb=0
+ vth0=dvtn + 0.552335 lvth0=1.105919e-08 wvth0=-1.638662e-07 pvth0=2.874375e-13
+ k1=0.5140873 lk1=-2.9124e-08 wk1=-4.094213e-07 pk1=9.38091e-13 k2=0.03640923 lk2=-8.183232e-09
+ wk2=-2.058394e-07 pk2=6.432856e-14 k3=0 dvt0=0 dvt1=0 dvt2=0 dvt0w=0 dvt1w=0 dvt2w=0
+ nlx=0 w0=0 k3b=0 vsat=93284.7 lvsat=0.002439456 wvsat=0.6445567 pvsat=-4.879294e-07
+ ua=0 ub=2.107241e-18 lub=-4.659615e-25 wub=3.129772e-23 pub=-1.756058e-29 uc=1.015095e-10
+ luc=-6.65921e-17 wuc=4.098089e-16 puc=3.627434e-22 rdsw=750 prwb=0 prwg=0 wr=1
+ u0=0.04695012 lu0=-1.967186e-09 wu0=1.962427e-07 pu0=-1.080658e-13 a0=1.123475
+ la0=-1.418531e-07 wa0=6.342665e-06 pa0=-7.540081e-12 keta=0.0194797 lketa=-1.778386e-08
+ wketa=9.20202e-08 pketa=8.370197e-14 a1=0 a2=0.99 ags=0.2366145 lags=-9.498365e-08
+ wags=7.387834e-06 pags=-7.279468e-12 b0=0 b1=0 voff=-0.0912467 lvoff=-8.83858e-09
+ wvoff=-1.750833e-06 pvoff=1.767891e-12 nfactor=1.222168 lnfactor=-5.706807e-08
+ wnfactor=-2.411932e-05 pnfactor=1.921913e-11 cit=-0.0004653787 lcit=2.443328e-10
+ wcit=1.884997e-08 pcit=-1.208655e-14 cdsc=0 cdscb=0 cdscd=0 eta0=0.001006312 leta0=-1.492144e-10
+ weta0=-1.672834e-08 peta0=1.395657e-14 etab=0.0004206679 letab=-4.867127e-10 wetab=-8.434391e-09
+ petab=9.758589e-15 dsub=0 pclm=1.103169 lpclm=-7.354388e-07 wpclm=-7.084521e-06
+ ppclm=1.571193e-11 pdiblc1=1e-05 pdiblc2=-0.0006830479 lpdiblc2=3.307666e-09 wpdiblc2=-8.79269e-09
+ ppdiblc2=1.7456e-14 pdiblcb=0.1651368 lpdiblcb=-3.052564e-08 wpdiblcb=-5.277212e-06
+ ppdiblcb=6.105734e-12 drout=0 pscbe1=5.782154e+08 lpscbe1=-91.24341 wpscbe1=-2414.635
+ ppscbe1=0.001078585 pscbe2=2.779844e-05 lpscbe2=-1.260797e-11 wpscbe2=-4.836938e-10
+ ppscbe2=2.688923e-16 pvag=0 delta=0.01 alpha0=2.5e-06 beta0=20.7 kt1=-0.356801
+ lkt1=6.597352e-08 wkt1=2.854991e-06 pkt1=-3.122749e-12 kt2=-0.01945076 lkt2=-2.003143e-09
+ wkt2=1.835831e-07 pkt2=-1.61786e-13 at=1906.944 lat=0.006801126 wat=-1.274016
+ pat=8.294801e-07 ute=-1.979571 lute=2.188354e-07 wute=-4.127272e-06 pute=-9.010521e-12
+ ua1=-2.167498e-10 lua1=3.730067e-16 wua1=1.302156e-14 pua1=-4.187434e-20 ub1=-1.302893e-18
+ lub1=1.485358e-24 wub1=-4.567962e-23 pub1=3.1813e-29 uc1=-3.468722e-10 luc1=3.403191e-16
+ wuc1=6.229855e-15 puc1=-6.274624e-21 kt1l=0 prt=-10.67252 lprt=4.558123e-06 wprt=-0.0002110901
+ pprt=1.769419e-10 cj=cjn cjsw=cjswn cjswg=cjswgn mj=0.3297355 mjsw=0.1303453 mjswg=0.1303453
+ pb=0.6944804 pbsw=0.6944804 pbswg=0.6944804 cta=9.42521e-4 ctp=4.91382e-04 pta=1.485657e-03
+ ptp=1.485657e-03 cgdo=cgon cgso=cgon xti=3 n=1 capmod=0 nqsmod=0 xpart=1 cf=0
+ js=6.27496e-05 jsw=5.79847e-10
//
//
     12: type=n minr=1e-60 lmin=3.5e-07 lmax=8.07e-07 - dxl wmin=1.9983e-5 - dxw wmax=0.0002001
+ tnom=25 version=3.1 ldif=1.2e-07 hdif=hdifn rsh=82.2 rd=0 rs=0 tox=toxn
+ xj=1e-07 nch=2.3579e+17 lln=1 lwn=1 wln=1 wwn=1 lint=4e-08 ll=0 lw=0 lwl=0 wint=4e-08
+ wl=0 ww=0 wwl=0 mobmod=1 binunit=2 xl=3e-08 + dxl xw=1.5e-07 + dxw dwg=0 dwb=0
+ vth0=dvtn + 0.558288 lvth0=6.552551e-09 wvth0=4.333969e-07 pvth0=-1.646906e-13
+ k1=0.4243538 lk1=3.880428e-08 wk1=1.293692e-06 pk1=-3.511657e-13 k2=0.05531685
+ lk2=-2.24963e-08 wk2=-2.018737e-07 pk2=6.132655e-14 k3=0 dvt0=0 dvt1=0 dvt2=0
+ dvt0w=0 dvt1w=0 dvt2w=0 nlx=0 w0=0 k3b=0 vsat=96507.23 ua=5.780811e-10 lua=-4.376074e-16
+ wua=-1.159052e-14 pua=8.774028e-21 ub=9.327076e-19 lub=4.231599e-25 wub=2.290615e-23
+ pub=-1.120815e-29 uc=-4.252817e-11 luc=4.244447e-17 wuc=2.133049e-15 puc=-9.417496e-22
+ rdsw=750 prwb=0 prwg=0 wr=1 u0=0.0493599 lu0=-3.791383e-09 wu0=-3.008583e-08 pu0=6.326492e-14
+ a0=1.108632 la0=-1.306164e-07 wa0=-7.754034e-06 pa0=3.131122e-12 keta=-0.002019476
+ lketa=-1.508986e-09 wketa=2.200248e-07 pketa=-1.319746e-14 a1=0 a2=0.99 ags=0.1805967
+ lags=-5.257816e-08 wags=5.250056e-07 pags=-2.084307e-12 b0=0 b1=0 voff=-0.1028186
+ lvoff=-7.862375e-11 wvoff=5.637835e-07 pvoff=1.572632e-14 nfactor=1.279284 lnfactor=-1.003055e-07
+ wnfactor=1.409367e-06 pnfactor=-1.060879e-13 cit=-0.0003548934 lcit=1.606955e-10
+ wcit=5.594149e-09 pcit=-2.051892e-15 cdsc=0 cdscb=0 cdscd=0 eta0=-0.0004200171
+ leta0=9.305167e-10 weta0=1.575515e-10 peta0=1.173948e-15 etab=0.0006617482 letab=-6.692105e-10
+ wetab=1.417605e-08 petab=-7.357516e-15 dsub=0 pclm=-0.09697377 lpclm=1.730695e-07
+ wpclm=1.778578e-05 ppclm=-3.114881e-12 pdiblc1=1e-05 pdiblc2=-0.0001322146 lpdiblc2=2.890686e-09
+ wpdiblc2=5.926362e-09 ppdiblc2=6.313672e-15 pdiblcb=0.09958895 lpdiblcb=1.909405e-08
+ wpdiblcb=5.088415e-06 ppdiblcb=-1.741046e-12 drout=0 pscbe1=4.648172e+08 lpscbe1=-5.401008
+ wpscbe1=-2351.523 ppscbe1=0.001030809 pscbe2=1.387722e-05 lpscbe2=-2.069607e-12
+ wpscbe2=-2.022001e-10 ppscbe2=5.580156e-17 pvag=0 delta=0.01 alpha0=2.5e-06 beta0=20.7
+ kt1=-0.1420202 lkt1=-9.661557e-08 wkt1=-4.90975e-06 pkt1=2.755161e-12 kt2=-0.01610689
+ lkt2=-4.534451e-09 wkt2=-2.62401e-07 pkt2=1.75824e-13 at=4458.583 lat=0.004869536
+ wat=-0.131913 pat=-3.509204e-08 ute=-1.801945 lute=8.437233e-08 wute=-1.71153e-05
+ pute=8.21413e-13 ua1=-6.043561e-10 lua1=6.664246e-16 wua1=-3.377768e-14 pua1=-6.447314e-21
+ ub1=1.551122e-18 lub1=-6.751311e-25 wub1=-1.52417e-23 pub1=8.77149e-30 uc1=2.179031e-10
+ luc1=-8.721581e-17 wuc1=-4.28415e-15 puc1=1.684478e-21 kt1l=0 prt=4.542504 lprt=-6.95965e-06
+ wprt=-7.738082e-05 pprt=7.5724e-11 cj=cjn cjsw=cjswn cjswg=cjswgn mj=0.3297355
+ mjsw=0.1303453 mjswg=0.1303453 pb=0.6944804 pbsw=0.6944804 pbswg=0.6944804 cta=9.42521e-4
+ ctp=4.91382e-04 pta=1.485657e-03 ptp=1.485657e-03 cgdo=cgon cgso=cgon xti=3 n=1
+ capmod=0 nqsmod=0 xpart=1 cf=0
+ js=6.27496e-05 jsw=5.79847e-10
//
//  *************************************************************
//                                                              *
//                3.3V PMOS DEVICES MODEL                       *
//                                                              *
//  *************************************************************
//
     }
model pch bsim3v3  {
     1: type=p minr=1e-60 lmin=1.2228e-06 - dxl lmax=2.01e-05 wmin=1.1823e-06 - dxw wmax=19.9823e-06
+ - dxw tnom=25 version=3.1 tlev=1 tlevc=1 ldif=1.2e-07 hdif=hdifp rsh=153
+ rd=0 rs=0 tox=toxp xj=1e-07 nch=8.52e+16 lln=1 lwn=1 wln=1 wwn=1 lint=5e-08 ll=0
+ lw=0 lwl=0 wint=5e-08 wl=0 ww=0 wwl=0 mobmod=1 binunit=2 xl=3e-08 + dxl xw=1.5e-07
+ + dxw dwg=0 dwb=0 vth0=dvtp - 0.7355598 lvth0=-2.602729e-08 wvth0=-6.917693e-08
+ pvth0=4.363606e-14 k1=0.4301047 lk1=-4.284528e-08 wk1=-6.316756e-08 pk1=5.673784e-14
+ k2=-0.0003689397 lk2=-5.71726e-09 wk2=1.353252e-08 pk2=-8.016593e-15 k3=0 dvt0=0
+ dvt1=0 dvt2=0 dvt0w=0 dvt1w=0 dvt2w=0 nlx=0 w0=0 k3b=0 vsat=250000 ua=1.0078e-09
+ lua=-4.527726e-16 wua=8.184941e-17 pua=-3.757546e-23 ub=1.534481e-18 lub=2.820746e-25
+ wub=-1.068201e-24 pub=3.569499e-31 uc=4.555716e-12 luc=-1.513726e-18 wuc=-9.126132e-17
+ puc=3.032344e-23 rdsw=900 prwb=0 prwg=0 wr=1 u0=0.0196312 lu0=-4.857933e-09 wu0=-4.780753e-09
+ pu0=3.105424e-16 a0=0.4467904 la0=-2.616579e-07 wa0=3.821818e-07 pa0=-7.26674e-14
+ keta=-0.005948482 lketa=-1.733205e-08 wketa=1.878229e-08 pketa=1.053462e-15 a1=0
+ a2=0.4 ags=0.01930433 lags=8.019689e-10 wags=1.393591e-08 pags=-1.606531e-14 b0=0
+ b1=0 voff=-0.1991839 lvoff=2.295196e-08 wvoff=-4.09161e-08 pvoff=3.040523e-14
+ nfactor=3.110217 lnfactor=-2.124369e-06 wnfactor=-6.45487e-07 pnfactor=1.496336e-12
+ cit=-0.0009357498 lcit=1.367298e-09 wcit=7.730287e-10 pcit=-1.122406e-15 cdsc=0
+ cdscb=-9.316545e-06 lcdscb=1.335765e-10 wcdscb=6.37953e-11 pcdscb=-2.249144e-16
+ cdscd=0 eta0=8.045419e-05 leta0=2.024863e-09 weta0=1.722021e-11 peta0=1.87748e-15
+ etab=-1.001222e-05 letab=1.343784e-10 wetab=7.773121e-11 petab=-2.409797e-16 dsub=0
+ pclm=2.432071 lpclm=-1.352396e-07 wpclm=1.629385e-06 ppclm=-2.650532e-12 pdiblc1=1e-05
+ pdiblc2=0.0001 pdiblcb=0.2976793 lpdiblcb=-3.29082e-07 wpdiblcb=-3.773149e-07
+ ppdiblcb=6.147268e-13 drout=0 pscbe1=6.241878e+08 pscbe2=1e-20 pvag=0 delta=0.01
+ alpha0=8e-09 beta0=18 kt1=-0.5176825 lkt1=-7.966352e-09 wkt1=1.360315e-08 pkt1=1.053899e-15
+ kt2=-0.03958106 lkt2=-2.860989e-09 wkt2=-2.070945e-08 pkt2=2.532487e-14 at=-50000
+ ute=-1.742463 lute=-5.778249e-07 wute=2.131611e-07 pute=5.872746e-13 ua1=-3.20746e-10
+ lua1=-2.415259e-15 wua1=5.988957e-17 pua1=2.375843e-21 ub1=-2.244901e-18 lub1=2.395018e-24
+ wub1=8.788389e-25 pub1=-2.61793e-30 uc1=-9.696401e-11 luc1=6.653525e-17 wuc1=7.734976e-17
+ puc1=-9.268197e-23 kt1l=0 prt=0 js=0.0001 jsw=8.5e-12 cj=cjp cjsw=cjswp cjswg=cjswgp
+ mj=0.6008857 mjsw=0.4471985 mjswg=0.4471985 pb=1.0864354 pbsw=1.0864354 pbswg=1.0864354
+ cta=9.168207e-4 ctp=1.441221e-3 pta=1.249266e-3 ptp=1.249266e-3 cgdo=cgop cgso=cgop
+ xti=3 n=1 capmod=0 nqsmod=0 xpart=1 cf=0
+
//
//
     2: type=p minr=1e-60 lmin=8.228e-07 - dxl lmax=1.2228e-06 - dxl wmin=1.1823e-06 - dxw
+ wmax=19.9823e-06 - dxw tnom=25 version=3.1 tlev=1 tlevc=1 ldif=1.2e-07
+ hdif=hdifp rsh=153 rd=0 rs=0 tox=toxp xj=1e-07 nch=8.52e+16 lln=1 lwn=1 wln=1
+ wwn=1 lint=5e-08 ll=0 lw=0 lwl=0 wint=5e-08 wl=0 ww=0 wwl=0 mobmod=1 binunit=2
+ xl=3e-08 + dxl xw=1.5e-07 + dxw dwg=0 dwb=0 vth0=dvtp - 0.766296 lvth0=9.405285e-09
+ wvth0=-2.838143e-08 pvth0=-3.392986e-15 k1=0.4032516 lk1=-1.188909e-08 wk1=-6.26186e-08
+ pk1=5.6105e-14 k2=-0.01627576 lk2=1.262012e-08 wk2=3.699832e-08 pk2=-3.506796e-14
+ k3=0 dvt0=0 dvt1=0 dvt2=0 dvt0w=0 dvt1w=0 dvt2w=0 nlx=0 w0=0 k3b=0 vsat=250000
+ ua=8.502457e-10 lua=-2.711436e-16 wua=2.974891e-16 pua=-2.861649e-22 ub=7.956685e-19
+ lub=1.133777e-24 wub=-6.748139e-25 pub=-9.654638e-32 uc=4.457796e-12 luc=-1.40085e-18
+ wuc=-8.929978e-17 puc=2.806218e-23 rdsw=900 prwb=0 prwg=0 wr=1 u0=0.01819144 lu0=-3.198179e-09
+ wu0=-5.180247e-09 pu0=7.710789e-16 a0=0.04032973 la0=2.069099e-07 wa0=8.760829e-07
+ pa0=-6.420366e-13 keta=-0.02118766 lketa=2.356817e-10 wketa=2.379156e-08 pketa=-4.721232e-15
+ a1=0 a2=0.4 ags=0.02 b0=0 b1=0 voff=-0.2186518 lvoff=4.53946e-08 wvoff=2.026846e-08
+ pvoff=-4.012832e-14 nfactor=-0.2299324 lnfactor=1.726156e-06 wnfactor=1.601439e-06
+ pnfactor=-1.09392e-12 cit=0.001390931 lcit=-1.314899e-09 wcit=-8.138641e-10 pcit=7.069634e-16
+ cdsc=0 cdscb=0.0002907382 lcdscb=-2.123266e-10 wcdscb=-4.278522e-10 pcdscb=3.418568e-16
+ cdscd=0 eta0=0.0001606131 leta0=1.932455e-09 weta0=8.750046e-09 peta0=-8.18972e-15
+ etab=9.491315e-05 letab=1.342048e-11 wetab=1.019006e-10 petab=-2.688422e-16 dsub=0
+ pclm=2.968812 lpclm=-7.539939e-07 wpclm=-3.166047e-06 ppclm=2.877641e-12 pdiblc1=1e-05
+ pdiblc2=0.0001 pdiblcb=-0.002433605 lpdiblcb=1.688803e-08 wpdiblcb=4.493959e-07
+ ppdiblcb=-3.383052e-13 drout=0 pscbe1=6.241878e+08 pscbe2=1e-20 pvag=0 delta=0.01
+ alpha0=8e-09 beta0=18 kt1=-0.4758361 lkt1=-5.62068e-08 wkt1=-2.242433e-08 pkt1=4.258637e-14
+ kt2=-0.04881256 lkt2=7.781083e-09 wkt2=1.664485e-08 pkt2=-1.773716e-14 at=-50000
+ ute=-2.643144 lute=4.604808e-07 wute=1.144958e-06 pute=-4.869005e-13 ua1=-2.449491e-09
+ lua1=3.875782e-17 wua1=2.794319e-15 pua1=-7.764063e-22 ub1=-3.7071e-19 lub1=2.344503e-25
+ wub1=-1.994584e-24 pub1=6.945517e-31 uc1=-4.638075e-11 luc1=8.222869e-18 wuc1=-1.142079e-16
+ puc1=1.281457e-22 kt1l=0 prt=0 js=0.0001 jsw=8.5e-12 cj=cjp cjsw=cjswp cjswg=cjswgp
+ mj=0.6008857 mjsw=0.4471985 mjswg=0.4471985 pb=1.0864354 pbsw=1.0864354 pbswg=1.0864354
+ cta=9.168207e-4 ctp=1.441221e-3 pta=1.249266e-3 ptp=1.249266e-3 cgdo=cgop cgso=cgop
+ xti=3 n=1 capmod=0 nqsmod=0 xpart=1 cf=0
+
//
//
     3: type=p minr=1e-60 lmin=3.5e-07 lmax=8.228e-07 - dxl wmin=1.1823e-06 - dxw wmax=19.9823e-06
+ - dxw tnom=25 version=3.1 tlev=1 tlevc=1 ldif=1.2e-07 hdif=hdifp rsh=153
+ rd=0 rs=0 tox=toxp xj=1e-07 nch=8.52e+16 lln=1 lwn=1 wln=1 wwn=1 lint=5e-08 ll=0
+ lw=0 lwl=0 wint=5e-08 wl=0 ww=0 wwl=0 mobmod=1 binunit=2 xl=3e-08 + dxl xw=1.5e-07
+ + dxw dwg=0 dwb=0 vth0=dvtp - 0.7757999 lvth0=1.655988e-08 wvth0=-1.74211e-08
+ pvth0=-1.164392e-14 k1=0.3485778 lk1=2.926939e-08 wk1=6.819686e-08 pk1=-4.237287e-14
+ k2=0.0150499 lk2=-1.096183e-08 wk2=-2.311111e-08 pk2=1.018241e-14 k3=0 dvt0=0
+ dvt1=0 dvt2=0 dvt0w=0 dvt1w=0 dvt2w=0 nlx=0 w0=0 k3b=0 vsat=234649.4 lvsat=0.01155597
+ wvsat=0.00233258 pvsat=-1.755967e-09 ua=4.846211e-10 lua=4.09865e-18 wua=-1.273793e-16
+ pua=3.3676e-23 ub=2.236267e-18 lub=4.929461e-26 wub=-1.019081e-24 pub=1.626178e-31
+ uc=3.662316e-12 luc=-8.020134e-19 wuc=-5.654456e-17 puc=3.404061e-24 rdsw=900
+ prwb=0 prwg=0 wr=1 u0=0.0160962 lu0=-1.620878e-09 wu0=-5.021799e-09 pu0=6.517988e-16
+ a0=-0.1255965 la0=3.318191e-07 wa0=-9.272605e-08 pa0=8.728277e-14 keta=-0.02604099
+ lketa=3.889268e-09 wketa=2.665836e-08 pketa=-6.879354e-15 a1=0 a2=0.4 ags=0.02507669
+ lags=-3.821729e-09 wags=-6.256e-09 pags=4.709516e-15 b0=0 b1=0 voff=-0.1943438
+ lvoff=2.709555e-08 wvoff=1.40105e-08 pvoff=-3.541732e-14 nfactor=1.717909 lnfactor=2.598207e-07
+ wnfactor=8.39973e-07 pnfactor=-5.206886e-13 cit=-0.0004053609 lcit=3.734908e-11
+ wcit=-1.720536e-10 pcit=2.238085e-16 cdsc=0 cdscb=1.585899e-05 lcdscb=-5.397541e-12
+ wcdscb=1.742596e-11 pcdscb=6.651389e-18 cdscd=0 eta0=-0.002082149 leta0=3.620807e-09
+ weta0=-4.331757e-09 peta0=1.65826e-15 etab=0.0001974238 letab=-6.37495e-11 wetab=-6.036696e-10
+ petab=2.623109e-16 dsub=0 pclm=2.539458 lpclm=-4.307759e-07 wpclm=1.260685e-06
+ ppclm=-4.548027e-13 pdiblc1=1e-05 pdiblc2=0.0001 pdiblcb=-0.05990779 lpdiblcb=6.015458e-08
+ drout=0 pscbe1=6.241878e+08 pscbe2=1e-20 pvag=0 delta=0.01 alpha0=8e-09 beta0=18
+ kt1=-0.5336035 lkt1=-1.27195e-08 wkt1=1.655252e-08 pkt1=1.324461e-14 kt2=-0.03884892
+ lkt2=2.804567e-10 wkt2=-1.052912e-08 pkt2=2.7194e-15 at=-95225.05 lat=0.03404541
+ wat=0.09719087 pat=-7.316528e-08 ute=-2.184161 lute=1.149584e-07 wute=4.57182e-07
+ pute=3.08571e-14 ua1=-3.235799e-09 lua1=6.306902e-16 wua1=2.370457e-15 pua1=-4.573231e-22
+ ub1=1.127105e-18 lub1=-8.931043e-25 wub1=-2.229754e-24 pub1=8.715877e-31 uc1=-3.854352e-11
+ luc1=2.322999e-18 wuc1=8.195983e-17 puc1=-1.952937e-23 kt1l=0 prt=0 js=0.0001
+ jsw=8.5e-12 cj=cjp cjsw=cjswp cjswg=cjswgp mj=0.6008857 mjsw=0.4471985 mjswg=0.4471985
+ pb=1.0864354 pbsw=1.0864354 pbswg=1.0864354 cta=9.168207e-4 ctp=1.441221e-3 pta=1.249266e-3
+ ptp=1.249266e-3 cgdo=cgop cgso=cgop xti=3 n=1 capmod=0 nqsmod=0 xpart=1 cf=0
+
//
//
     4: type=p minr=1e-60 lmin=1.2228e-06 - dxl lmax=2.01e-05 wmin=7.823e-07 - dxw wmax=1.1823e-06
+ - dxw tnom=25 version=3.1 tlev=1 tlevc=1 ldif=1.2e-07 hdif=hdifp rsh=153
+ rd=0 rs=0 tox=toxp xj=1e-07 nch=8.52e+16 lln=1 lwn=1 wln=1 wwn=1 lint=5e-08 ll=0
+ lw=0 lwl=0 wint=5e-08 wl=0 ww=0 wwl=0 mobmod=1 binunit=2 xl=3e-08 + dxl xw=1.5e-07
+ + dxw dwg=0 dwb=0 vth0=dvtp - 0.7866083 lvth0=1.057459e-08 wvth0=-6.269882e-09
+ pvth0=-1.468425e-15 k1=0.4168567 lk1=-5.362176e-08 wk1=-4.684214e-08 pk1=7.001769e-14
+ k2=-0.01016741 lk2=1.17565e-08 wk2=2.560718e-08 pk2=-2.954951e-14 k3=0 dvt0=0
+ dvt1=0 dvt2=0 dvt0w=0 dvt1w=0 dvt2w=0 nlx=0 w0=0 k3b=0 vsat=250000 ua=1.073501e-09
+ lua=-5.706369e-16 wua=8.85903e-19 pua=1.076688e-22 ub=7.214213e-19 lub=7.715838e-25
+ wub=-6.626779e-26 pub=-2.462722e-31 uc=-8.183195e-11 luc=4.574169e-17 wuc=1.519419e-17
+ puc=-2.79094e-23 rdsw=900 prwb=0 prwg=0 wr=1 u0=0.01589529 lu0=-5.685544e-09 wu0=-1.769906e-10
+ pu0=1.330407e-15 a0=0.3231201 la0=2.88096e-07 wa0=5.345807e-07 pa0=-7.501292e-13
+ keta=-0.01755726 lketa=1.927339e-08 wketa=3.308779e-08 pketa=-4.405541e-14 a1=0
+ a2=0.4 ags=0.05269657 lags=-3.769262e-08 wags=-2.721336e-08 pags=3.137156e-14
+ b0=0 b1=0 voff=-0.1879437 lvoff=-8.806627e-09 wvoff=-5.476744e-08 pvoff=6.954134e-14
+ nfactor=2.680395 lnfactor=-1.280679e-06 wnfactor=-1.15817e-07 pnfactor=4.56657e-13
+ cit=-0.0005696733 lcit=1.123578e-09 wcit=3.219128e-10 pcit=-8.220703e-16 cdsc=0
+ cdscb=2.419705e-05 lcdscb=-9.985501e-11 wcdscb=2.249651e-11 pcdscb=6.274313e-17
+ cdscd=0 eta0=0.0001178861 leta0=7.34801e-09 weta0=-2.890688e-11 peta0=-4.682234e-15
+ etab=0.002119739 letab=-2.923373e-09 wetab=-2.546761e-09 petab=3.527087e-15 dsub=0
+ pclm=4.492218 lpclm=-4.954977e-06 wpclm=-9.093341e-07 ppclm=3.28883e-12 pdiblc1=1e-05
+ pdiblc2=0.0001 pdiblcb=-0.3149227 lpdiblcb=5.229975e-07 wpdiblcb=3.775945e-07
+ ppdiblcb=-4.352909e-13 drout=0 pscbe1=6.241878e+08 pscbe2=1e-20 pvag=0 delta=0.01
+ alpha0=8e-09 beta0=18 kt1=-0.5579297 lkt1=6.130227e-08 wkt1=6.319981e-08 pkt1=-8.430581e-14
+ kt2=-0.07751723 lkt2=5.684131e-08 wkt2=2.60393e-08 pkt2=-4.824628e-14 at=-49999.96
+ ute=-1.851253 lute=6.268078e-08 wute=3.472238e-07 pute=-2.020204e-13 ua1=-1.409633e-09
+ lua1=1.185729e-15 wua1=1.401725e-15 pua1=-2.061654e-21 ub1=-1.114705e-18 lub1=-1.262137e-24
+ wub1=-5.139017e-25 pub1=1.888781e-30 uc1=-1.5418e-10 luc1=2.956761e-17 wuc1=1.47857e-16
+ puc1=-4.712678e-23 kt1l=0 prt=0 js=0.0001 jsw=8.5e-12 cj=cjp cjsw=cjswp cjswg=cjswgp
+ mj=0.6008857 mjsw=0.4471985 mjswg=0.4471985 pb=1.0864354 pbsw=1.0864354 pbswg=1.0864354
+ cta=9.168207e-4 ctp=1.441221e-3 pta=1.249266e-3 ptp=1.249266e-3 cgdo=cgop cgso=cgop
+ xti=3 n=1 capmod=0 nqsmod=0 xpart=1 cf=0
+
//
//
     5: type=p minr=1e-60 lmin=8.228e-07 - dxl lmax=1.2228e-06 - dxl wmin=7.823e-07 - dxw wmax=1.1823e-06
+ - dxw tnom=25 version=3.1 tlev=1 tlevc=1 ldif=1.2e-07 hdif=hdifp rsh=153
+ rd=0 rs=0 tox=toxp xj=1e-07 nch=8.52e+16 lln=1 lwn=1 wln=1 wwn=1 lint=5e-08 ll=0
+ lw=0 lwl=0 wint=5e-08 wl=0 ww=0 wwl=0 mobmod=1 binunit=2 xl=3e-08 + dxl xw=1.5e-07
+ + dxw dwg=0 dwb=0 vth0=dvtp - 0.779176 lvth0=2.006595e-09 wvth0=-1.250934e-08
+ pvth0=5.724419e-15 k1=0.2097173 lk1=1.851686e-07 wk1=1.758737e-07 pk1=-1.867292e-13
+ k2=0.04239342 lk2=-4.883562e-08 wk2=-3.52997e-08 pk2=4.066394e-14 k3=0 dvt0=0
+ dvt1=0 dvt2=0 dvt0w=0 dvt1w=0 dvt2w=0 nlx=0 w0=0 k3b=0 vsat=250000 ua=8.325413e-10
+ lua=-2.928581e-16 wua=3.193063e-16 pua=-2.594061e-22 ub=-5.959466e-19 lub=2.290246e-24
+ wub=1.040073e-24 pub=-1.521662e-30 uc=-8.300034e-11 luc=4.708861e-17 wuc=1.847488e-17
+ puc=-3.169138e-23 rdsw=900 prwb=0 prwg=0 wr=1 u0=0.01158579 lu0=-7.17551e-10 wu0=2.959899e-09
+ pu0=-2.285799e-15 a0=1.164632 la0=-6.819982e-07 wa0=-5.093941e-07 pa0=4.533647e-13
+ keta=0.01289531 lketa=-1.583234e-08 wketa=-1.820888e-08 pketa=1.507939e-14 a1=0
+ a2=0.4 ags=0.02 b0=0 b1=0 voff=-0.2218014 lvoff=3.022459e-08 wvoff=2.41497e-08
+ pvoff=-2.143433e-14 nfactor=-1.319543 lnfactor=3.330449e-06 wnfactor=2.944166e-06
+ pnfactor=-3.070891e-12 cit=0.003063496 lcit=-3.064739e-09 wcit=-2.874966e-09 pcit=2.863291e-15
+ cdsc=0 cdscb=-0.0002363616 lcdscb=2.00517e-10 wcdscb=2.216928e-10 pcdscb=-1.668903e-16
+ cdscd=0 eta0=0.01878576 leta0=-1.417231e-08 weta0=-1.420172e-08 peta0=1.165619e-14
+ etab=0.0001815055 letab=-6.889773e-10 wetab=-4.807217e-12 petab=5.967225e-16 dsub=0
+ pclm=-5.086017 lpclm=6.086812e-06 wpclm=6.759918e-06 ppclm=-5.552283e-12 pdiblc1=1e-05
+ pdiblc2=0.0001 pdiblcb=0.362247 lpdiblcb=-2.576436e-07 drout=0 pscbe1=6.241878e+08
+ pscbe2=1e-20 pvag=0 delta=0.01 alpha0=8e-09 beta0=18 kt1=-0.5147027 lkt1=1.147023e-08
+ wkt1=2.547098e-08 pkt1=-4.081202e-14 kt2=-0.001345327 lkt2=-3.096966e-08 wkt2=-4.184902e-08
+ pkt2=3.001538e-14 at=-50000 ute=-2.214676 lute=4.81635e-07 wute=6.169569e-07 pute=-5.129688e-13
+ ua1=-6.098145e-11 lua1=-3.689957e-16 wua1=-1.490411e-16 pua1=-2.739316e-22 ub1=-2.362473e-18
+ lub1=1.762899e-25 wub1=4.59865e-25 pub1=7.662229e-31 uc1=-3.500879e-10 luc1=2.554103e-16
+ wuc1=2.600504e-16 puc1=-1.764633e-22 kt1l=0 prt=0 js=0.0001 jsw=8.5e-12 cj=cjp
+ cjsw=cjswp cjswg=cjswgp mj=0.6008857 mjsw=0.4471985 mjswg=0.4471985 pb=1.0864354
+ pbsw=1.0864354 pbswg=1.0864354 cta=9.168207e-4 ctp=1.441221e-3 pta=1.249266e-3
+ ptp=1.249266e-3 cgdo=cgop cgso=cgop xti=3 n=1 capmod=0 nqsmod=0 xpart=1 cf=0
+
//
//
     6: type=p minr=1e-60 lmin=3.5e-07 lmax=8.228e-07 - dxl wmin=7.823e-07 - dxw wmax=1.1823e-06
+ - dxw tnom=25 version=3.1 tlev=1 tlevc=1 ldif=1.2e-07 hdif=hdifp rsh=153
+ rd=0 rs=0 tox=toxp xj=1e-07 nch=8.52e+16 lln=1 lwn=1 wln=1 wwn=1 lint=5e-08 ll=0
+ lw=0 lwl=0 wint=5e-08 wl=0 ww=0 wwl=0 mobmod=1 binunit=2 xl=3e-08 + dxl xw=1.5e-07
+ + dxw dwg=0 dwb=0 vth0=dvtp - 0.7641595 lvth0=-9.297831e-09 wvth0=-3.176559e-08
+ pvth0=2.022053e-14 k1=0.5075374 lk1=-3.903041e-08 wk1=-1.276891e-07 pk1=4.179296e-14
+ k2=-0.02724116 lk2=3.585289e-09 wk2=2.900416e-08 pk2=-7.744009e-15 k3=0 dvt0=0
+ dvt1=0 dvt2=0 dvt0w=0 dvt1w=0 dvt2w=0 nlx=0 w0=0 k3b=0 vsat=208540 lvsat=0.03121112
+ wvsat=0.0345072 pvsat=-2.597702e-08 ua=4.029183e-10 lua=3.056212e-17 wua=-2.669692e-17
+ pua=1.065072e-24 ub=2.37556e-18 lub=5.329574e-26 wub=-1.190731e-24 pub=1.576872e-31
+ uc=-9.487141e-12 luc=-8.252123e-18 wuc=-4.034049e-17 puc=1.258483e-23 rdsw=900
+ prwb=0 prwg=0 wr=1 u0=0.01219331 lu0=-1.174895e-09 wu0=-2.122757e-10 pu0=1.022139e-16
+ a0=-1.103584 la0=1.025515e-06 wa0=1.112448e-06 pa0=-7.675582e-13 keta=-0.01097397
+ lketa=2.136461e-09 wketa=8.091276e-09 pketa=-4.719369e-15 a1=0 a2=0.4 ags=0.02
+ b0=0 b1=0 voff=-0.1698755 lvoff=-8.865221e-09 wvoff=-1.614182e-08 pvoff=8.897133e-15
+ nfactor=3.666665 lnfactor=-4.231673e-07 wnfactor=-1.561478e-06 pnfactor=3.209575e-13
+ cit=-0.00176165 lcit=5.676309e-10 wcit=1.499302e-09 pcit=-4.296576e-16 cdsc=0
+ cdscb=3e-05 cdscd=0 eta0=-0.01347405 leta0=1.011287e-08 weta0=9.70648e-09 peta0=-6.341908e-15
+ etab=-0.001790114 letab=7.952579e-10 wetab=1.845573e-09 petab=-7.962437e-16 dsub=0
+ pclm=5.310853 lpclm=-1.739951e-06 wpclm=-2.154504e-06 ppclm=1.158494e-12 pdiblc1=1e-05
+ pdiblc2=0.0001 pdiblcb=-0.05990779 lpdiblcb=6.015458e-08 drout=0 pscbe1=6.241878e+08
+ pscbe2=1e-20 pvag=0 delta=0.01 alpha0=8e-09 beta0=18 kt1=-0.463275 lkt1=-2.724455e-08
+ wkt1=-7.011332e-08 pkt1=3.114384e-14 kt2=-0.04331045 lkt2=6.21685e-10 wkt2=-5.031174e-09
+ pkt2=2.298904e-15 at=-16355.55 lat=-0.02532754 ute=-1.682923 lute=8.133089e-08
+ wute=-1.604939e-07 pute=7.229621e-14 ua1=-3.270858e-10 lua1=-1.686723e-16 wua1=-1.213949e-15
+ pua1=5.277313e-22 ub1=-3.007486e-18 lub1=6.618557e-25 wub1=2.865301e-24 pub1=-1.044589e-30
+ uc1=3.054052e-11 luc1=-3.11268e-17 wuc1=-3.172416e-18 puc1=2.169081e-23 kt1l=0
+ prt=0 js=0.0001 jsw=8.5e-12 cj=cjp cjsw=cjswp cjswg=cjswgp mj=0.6008857 mjsw=0.4471985
+ mjswg=0.4471985 pb=1.0864354 pbsw=1.0864354 pbswg=1.0864354 cta=9.168207e-4 ctp=1.441221e-3
+ pta=1.249266e-3 ptp=1.249266e-3 cgdo=cgop cgso=cgop xti=3 n=1 capmod=0 nqsmod=0
+ xpart=1 cf=0
//
//
     7: type=p minr=1e-60 lmin=1.2228e-06 - dxl lmax=2.01e-05 wmin=4e-07 wmax=7.823e-07 - dxw
+ tnom=25 version=3.1 tlev=1 tlevc=1 ldif=1.2e-07 hdif=hdifp rsh=153 rd=0
+ rs=0 tox=toxp xj=1e-07 nch=8.52e+16 lln=1 lwn=1 wln=1 wwn=1 lint=5e-08 ll=0 lw=0
+ lwl=0 wint=5e-08 wl=0 ww=0 wwl=0 mobmod=1 binunit=2 xl=3e-08 + dxl xw=1.5e-07
+ + dxw dwg=0 dwb=0 vth0=dvtp - 0.7029392 lvth0=-4.451755e-08 wvth0=-7.590772e-08
+ pvth0=4.438476e-14 k1=0.3443789 lk1=8.180757e-08 wk1=1.348116e-08 pk1=-4.270013e-14
+ k2=0.01761105 lk2=-4.877357e-08 wk2=2.487164e-09 pk2=2.082967e-14 k3=0 dvt0=0
+ dvt1=0 dvt2=0 dvt0w=0 dvt1w=0 dvt2w=0 nlx=0 w0=0 k3b=0 vsat=250000 ua=1.066756e-09
+ lua=-2.483758e-16 wua=6.500119e-18 pua=-1.605491e-22 ub=9.346848e-19 lub=5.150803e-25
+ wub=-2.43767e-25 pub=-3.278438e-32 uc=-4.907086e-11 luc=1.301524e-17 wuc=-1.207287e-17
+ puc=-6.711811e-25 rdsw=900 prwb=0 prwg=0 wr=1 u0=0.01576646 lu0=-4.720393e-09
+ wu0=-6.976555e-11 pu0=5.271125e-16 a0=1.06084 la0=-1.011976e-06 wa0=-7.942362e-08
+ pa0=3.319203e-13 keta=0.04255971 lketa=-6.234864e-08 wketa=-1.694756e-08 pketa=2.38786e-14
+ a1=0 a2=0.4 ags=0.02 b0=0 b1=0 voff=-0.237276 lvoff=6.958046e-08 wvoff=-1.370811e-08
+ pvoff=4.29978e-15 nfactor=3.356886 lnfactor=-2.514415e-06 wnfactor=-6.788601e-07
+ pnfactor=1.483495e-12 cit=-0.001227871 lcit=1.821105e-09 wcit=8.697309e-10 pcit=-1.402622e-15
+ cdsc=0 cdscb=7.549221e-05 lcdscb=-7.736119e-11 wcdscb=-2.019645e-11 pcdscb=4.402152e-17
+ cdscd=0 eta0=-0.0001047156 leta0=2.308267e-09 weta0=1.563642e-10 peta0=-4.876564e-16
+ etab=-0.00198557 letab=2.45723e-09 wetab=8.70087e-10 petab=-9.511886e-16 dsub=0
+ pclm=3.781351 lpclm=-1.085423e-06 wpclm=-3.176793e-07 ppclm=6.820034e-14 pdiblc1=1e-05
+ pdiblc2=0.0001 pdiblcb=0.2670959 wpdiblcb=-1.068196e-07 drout=0 pscbe1=6.241878e+08
+ pscbe2=1e-20 pvag=0 delta=0.01 alpha0=8e-09 beta0=18 kt1=-0.4769646 lkt1=-5.411961e-08
+ wkt1=-4.187418e-09 pkt1=1.17598e-14 kt2=-0.02597249 lkt2=-1.477262e-08 wkt2=-1.686139e-08
+ pkt2=1.1358e-14 at=-50000 ute=-1.196817 lute=-7.116914e-07 wute=-1.974633e-07
+ pute=4.424896e-13 ua1=3.5086e-10 lua1=-2.020732e-15 wua1=-6.353342e-17 pua1=6.070835e-22
+ ub1=-6.322137e-19 lub1=-5.977636e-25 wub1=-9.154795e-25 pub1=1.335823e-30 uc1=5.761773e-11
+ luc1=-1.162573e-16 wuc1=-2.842223e-17 puc1=7.424327e-23 kt1l=0 prt=0 js=0.0001
+ jsw=8.5e-12 cj=cjp cjsw=cjswp cjswg=cjswgp mj=0.6008857 mjsw=0.4471985 mjswg=0.4471985
+ pb=1.0864354 pbsw=1.0864354 pbswg=1.0864354 cta=9.168207e-4 ctp=1.441221e-3 pta=1.249266e-3
+ ptp=1.249266e-3 cgdo=cgop cgso=cgop xti=3 n=1 capmod=0 nqsmod=0 xpart=1 cf=0
+
//
//
     8: type=p minr=1e-60 lmin=8.228e-07 - dxl lmax=1.2228e-06 - dxl wmin=4e-07 wmax=7.823e-07
+ - dxw tnom=25 version=3.1 tlev=1 tlevc=1 ldif=1.2e-07 hdif=hdifp rsh=153
+ rd=0 rs=0 tox=toxp xj=1e-07 nch=8.52e+16 lln=1 lwn=1 wln=1 wwn=1 lint=5e-08 ll=0
+ lw=0 lwl=0 wint=5e-08 wl=0 ww=0 wwl=0 mobmod=1 binunit=2 xl=3e-08 + dxl xw=1.5e-07
+ + dxw dwg=0 dwb=0 vth0=dvtp - 0.7488175 lvth0=8.370963e-09 wvth0=-3.777674e-08
+ pvth0=4.273592e-16 k1=0.523604 lk1=-1.248031e-07 wk1=-8.537419e-08 pk1=7.126033e-14
+ k2=-0.05107869 lk2=3.041198e-08 wk2=4.249714e-08 pk2=-2.529384e-14 k3=0 dvt0=0
+ dvt1=0 dvt2=0 dvt0w=0 dvt1w=0 dvt2w=0 nlx=0 w0=0 k3b=0 vsat=250000 ua=1.920242e-09
+ lua=-1.232275e-15 wua=-5.859873e-16 pua=5.224705e-22 ub=8.263419e-19 lub=6.399782e-25
+ wub=-1.43697e-25 pub=-1.481451e-31 uc=-2.361161e-11 luc=-1.633418e-17 wuc=-3.095436e-17
+ puc=2.109541e-23 rdsw=900 prwb=0 prwg=0 wr=1 u0=0.01692046 lu0=-6.05072e-09 wu0=-1.480145e-09
+ pu0=2.152998e-15 a0=0.4326881 la0=-2.87842e-07 wa0=9.980239e-08 pa0=1.253086e-13
+ keta=-0.02037767 lketa=1.020558e-08 wketa=9.484226e-09 pketa=-6.591972e-15 a1=0
+ a2=0.4 ags=0.02 b0=0 b1=0 voff=-0.1646493 lvoff=-1.414362e-08 wvoff=-2.3418e-08
+ pvoff=1.549334e-14 nfactor=0.8098734 lnfactor=4.217814e-07 wnfactor=1.171853e-06
+ pnfactor=-6.500073e-13 cit=0.0004857531 lcit=-1.543615e-10 wcit=-7.29511e-10 pcit=4.409841e-16
+ cdsc=0 cdscb=-1.19547e-05 lcdscb=2.344761e-11 wcdscb=3.49189e-11 pcdscb=-1.951545e-17
+ cdscd=0 eta0=0.003195406 leta0=-1.496113e-09 weta0=-1.225872e-09 peta0=1.105785e-15
+ etab=-0.0001486143 letab=3.395882e-10 wetab=2.699516e-10 petab=-2.593526e-16 dsub=0
+ pclm=3.857132 lpclm=-1.172783e-06 wpclm=-6.834642e-07 ppclm=4.898773e-13 pdiblc1=1e-05
+ pdiblc2=0.0001 pdiblcb=0.973671 lpdiblcb=-8.145399e-07 wpdiblcb=-5.088884e-07
+ ppdiblcb=4.635049e-13 drout=0 pscbe1=6.241878e+08 pscbe2=1e-20 pvag=0 delta=0.01
+ alpha0=8e-09 beta0=18 kt1=-0.5435685 lkt1=2.266135e-08 wkt1=4.949596e-08 pkt1=-5.01264e-14
+ kt2=-0.04533644 lkt2=7.550143e-09 wkt2=-5.235222e-09 pkt2=-2.044651e-15 at=-50000
+ ute=-1.910263 lute=1.107694e-07 wute=3.635942e-07 pute=-2.042974e-13 ua1=-1.618861e-09
+ lua1=2.49963e-16 wua1=1.147583e-15 pua1=-7.890911e-22 ub1=-1.710158e-18 lub1=6.4489e-25
+ wub1=-8.305712e-26 pub1=3.76207e-31 uc1=-1.616186e-10 luc1=1.364784e-16 wuc1=1.031874e-16
+ puc1=-7.747635e-23 kt1l=0 prt=0 js=0.0001 jsw=8.5e-12 cj=cjp cjsw=cjswp cjswg=cjswgp
+ mj=0.6008857 mjsw=0.4471985 mjswg=0.4471985 pb=1.0864354 pbsw=1.0864354 pbswg=1.0864354
+ cta=9.168207e-4 ctp=1.441221e-3 pta=1.249266e-3 ptp=1.249266e-3 cgdo=cgop cgso=cgop
+ xti=3 n=1 capmod=0 nqsmod=0 xpart=1 cf=0
+
//
//
     9: type=p minr=1e-60 lmin=3.5e-07 lmax=8.228e-07 - dxl wmin=4e-07 wmax=7.823e-07 - dxw
+ tnom=25 version=3.1 tlev=1 tlevc=1 ldif=1.2e-07 hdif=hdifp rsh=153 rd=0
+ rs=0 tox=toxp xj=1e-07 nch=8.52e+16 lln=1 lwn=1 wln=1 wwn=1 lint=5e-08 ll=0 lw=0
+ lwl=0 wint=5e-08 wl=0 ww=0 wwl=0 mobmod=1 binunit=2 xl=3e-08 + dxl xw=1.5e-07
+ + dxw dwg=0 dwb=0 vth0=dvtp - 0.7272227 lvth0=-7.885572e-09 wvth0=-6.250807e-08
+ pvth0=1.904511e-14 k1=0.3380176 lk1=1.490627e-08 wk1=1.340218e-08 pk1=-3.09853e-15
+ k2=-0.008506408 lk2=-1.636434e-09 wk2=1.341123e-08 pk2=-3.39797e-15 k3=0 dvt0=0
+ dvt1=0 dvt2=0 dvt0w=0 dvt1w=0 dvt2w=0 nlx=0 w0=0 k3b=0 vsat=250000 ua=1.397638e-10
+ lua=1.080694e-16 wua=1.923266e-16 pua=-6.344423e-23 ub=1.316753e-18 lub=2.70797e-25
+ wub=-3.094861e-25 pub=-2.33391e-32 uc=-7.052166e-11 luc=1.897971e-17 wuc=1.045854e-17
+ puc=-1.008023e-23 rdsw=900 prwb=0 prwg=0 wr=1 u0=0.009777177 lu0=-6.732601e-10
+ wu0=1.798674e-09 pu0=-3.152969e-16 a0=0.08632154 la0=-2.709721e-08 wa0=1.220898e-07
+ pa0=1.085306e-13 keta=-0.0005893141 lketa=-4.691097e-09 wketa=-5.518763e-10 pketa=9.632065e-16
+ a1=0 a2=0.4 ags=-0.009088973 lags=2.189819e-08 wags=2.421076e-08 pags=-1.822586e-14
+ b0=0 b1=0 voff=-0.1157581 lvoff=-5.094894e-08 wvoff=-6.118378e-08 pvoff=4.392342e-14
+ nfactor=1.598914 lnfactor=-1.722084e-07 wnfactor=1.595103e-07 pnfactor=1.120844e-13
+ cit=0.0002671651 lcit=1.019156e-11 wcit=-1.89281e-10 pcit=3.429902e-17 cdsc=0
+ cdscb=-9.896482e-06 lcdscb=2.189819e-11 wcdscb=3.320585e-11 pcdscb=-1.822586e-17
+ cdscd=0 eta0=-0.002054754 leta0=2.456208e-09 weta0=2.022026e-10 peta0=3.073108e-17
+ etab=0.0005813941 letab=-2.099622e-10 wetab=-1.28233e-10 petab=4.040082e-17 dsub=0
+ pclm=2.745758 lpclm=-3.361407e-07 wpclm=-1.957624e-08 ppclm=-9.897592e-15 pdiblc1=1e-05
+ pdiblc2=0.0001 pdiblcb=-0.360971 lpdiblcb=1.901786e-07 wpdiblcb=2.50575e-07 ppdiblcb=-1.082191e-13
+ drout=0 pscbe1=6.241878e+08 pscbe2=1e-20 pvag=0 delta=0.01 alpha0=8e-09 beta0=18
+ kt1=-0.518584 lkt1=3.853044e-09 wkt1=-2.407964e-08 pkt1=5.26131e-15 kt2=-0.03174964
+ lkt2=-2.678e-09 wkt2=-1.465324e-08 pkt2=5.045232e-15 at=63639.13 lat=-0.08554755
+ wat=-0.0665796 pat=5.012112e-08 ute=-2.026918 lute=1.985872e-07 wute=1.258136e-07
+ pute=-2.529622e-14 ua1=-1.788096e-09 lua1=3.773624e-16 wua1=2.04894e-18 pua1=7.326666e-23
+ ub1=-3.558863e-19 lub1=-3.746053e-25 wub1=6.583748e-25 pub1=-1.81943e-31 uc1=8.369506e-12
+ luc1=8.511368e-18 wuc1=1.528052e-17 puc1=-1.130004e-23 kt1l=0 prt=0 js=0.0001
+ jsw=8.5e-12 cj=cjp cjsw=cjswp cjswg=cjswgp mj=0.6008857 mjsw=0.4471985 mjswg=0.4471985
+ pb=1.0864354 pbsw=1.0864354 pbswg=1.0864354 cta=9.168207e-4 ctp=1.441221e-3 pta=1.249266e-3
+ ptp=1.249266e-3 cgdo=cgop cgso=cgop xti=3 n=1 capmod=0 nqsmod=0 xpart=1 cf=0
+
//
//
     10: type=p minr=1e-60 lmin=1.2228e-06 - dxl lmax=2.01e-05 wmin=19.9823e-06 - dxw wmax=0.0002001
+ tnom=25 version=3.1 tlev=1 tlevc=1 ldif=1.2e-07 hdif=hdifp rsh=153 rd=0
+ rs=0 tox=toxp xj=1e-07 nch=8.52e+16 lln=1 lwn=1 wln=1 wwn=1 lint=5e-08 ll=0 lw=0
+ lwl=0 wint=5e-08 wl=0 ww=0 wwl=0 mobmod=1 binunit=2 xl=3e-08 + dxl xw=1.5e-07
+ + dxw dwg=0 dwb=0 vth0=dvtp - 0.7371827 lvth0=-1.466368e-08 wvth0=-3.666763e-08
+ pvth0=-1.840033e-13 k1=0.3736005 lk1=9.856357e-09 wk1=1.068742e-06 pk1=-9.989972e-13
+ k2=0.004450029 lk2=-4.488514e-09 wk2=-8.300249e-08 pk2=-3.263122e-14 k3=0 dvt0=0
+ dvt1=0 dvt2=0 dvt0w=0 dvt1w=0 dvt2w=0 nlx=0 w0=0 k3b=0 vsat=250000 ua=1.665056e-09
+ lua=-1.050176e-15 wua=-1.308449e-14 pua=1.192978e-20 ub=5.963167e-19 lub=1.639836e-24
+ wub=1.772538e-23 pub=-2.684213e-29 uc=-5.989704e-11 luc=5.769085e-17 wuc=1.199875e-15
+ puc=-1.15568e-21 rdsw=900 prwb=0 prwg=0 wr=1 u0=0.02129731 lu0=-6.572549e-09 wu0=-3.815676e-08
+ pu0=3.465824e-14 a0=0.6007706 la0=-3.710333e-07 wa0=-2.702396e-06 pa0=2.118372e-12
+ keta=-0.003602454 lketa=-1.890309e-08 wketa=-2.8214e-08 pketa=3.252511e-14 a1=0
+ a2=0.4 ags=0.03179434 lags=-1.359651e-08 wags=-2.362677e-07 pags=2.723694e-13
+ b0=0 b1=0 voff=-0.09644017 lvoff=-7.070584e-08 wvoff=-2.099109e-06 pvoff=1.906586e-12
+ nfactor=3.063436 lnfactor=9.926317e-07 wnfactor=2.916542e-07 pnfactor=-6.094435e-11
+ cit=-0.001396489 lcit=-4.456357e-10 wcit=1.00027e-08 pcit=3.519482e-14 cdsc=0
+ cdscb=0.0002640108 lcdscb=-2.787483e-10 wcdscb=-5.411579e-09 pcdscb=8.034899e-15
+ cdscd=0 eta0=7.950994e-05 leta0=2.835853e-09 weta0=3.613733e-11 peta0=-1.436851e-14
+ etab=4.104545e-05 letab=6.79628e-11 wetab=-9.45071e-10 petab=1.089478e-15 dsub=0
+ pclm=5.481165 lpclm=-4.049179e-06 wpclm=-5.945097e-05 ppclm=7.575467e-11 pdiblc1=1e-05
+ pdiblc2=0.0001 pdiblcb=-0.008806934 lpdiblcb=3.320864e-08 wpdiblcb=5.762309e-06
+ ppdiblcb=-6.642789e-12 drout=0 pscbe1=6.241878e+08 pscbe2=1e-20 pvag=0 delta=0.01
+ alpha0=8e-09 beta0=18 kt1=-0.4967754 lkt1=-7.004862e-08 wkt1=-4.052139e-07 pkt1=1.244704e-12
+ kt2=-0.06552477 lkt2=2.301985e-08 wkt2=4.990029e-07 pkt2=-4.931279e-13 at=-15423.63
+ lat=0.4187727 wat=-0.6926445 pat=-8.38898e-06 ute=-1.721768 lute=-4.373057e-07
+ wute=-2.013997e-07 pute=-2.227647e-12 ua1=-1.471929e-09 lua1=-1.255656e-15 wua1=2.312073e-14
+ pua1=-2.085367e-20 ub1=7.951824e-20 lub1=-6.762104e-25 wub1=-4.568463e-23 pub1=5.890584e-29
+ uc1=4.279592e-11 luc1=-4.428028e-17 wuc1=-2.722363e-15 puc1=2.127207e-21 kt1l=0
+ prt=0 js=0.0001 jsw=8.5e-12 cj=cjp cjsw=cjswp cjswg=cjswgp mj=0.6008857 mjsw=0.4471985
+ mjswg=0.4471985 pb=1.0864354 pbsw=1.0864354 pbswg=1.0864354 cta=9.168207e-4 ctp=1.441221e-3
+ pta=1.249266e-3 ptp=1.249266e-3 cgdo=cgop cgso=cgop xti=3 n=1 capmod=0 nqsmod=0
+ xpart=1 cf=0
//
//
     11: type=p minr=1e-60 lmin=8.228e-07 - dxl lmax=1.2228e-06 - dxl wmin=19.9823e-06 - dxw
+ wmax=0.0002001 tnom=25 version=3.1 tlev=1 tlevc=1 ldif=1.2e-07 hdif=hdifp
+ rsh=153 rd=0 rs=0 tox=toxp xj=1e-07 nch=8.52e+16 lln=1 lwn=1 wln=1 wwn=1 lint=5e-08
+ ll=0 lw=0 lwl=0 wint=5e-08 wl=0 ww=0 wwl=0 mobmod=1 binunit=2 xl=3e-08 + dxl xw=1.5e-07
+ + dxw dwg=0 dwb=0 vth0=dvtp - 0.7569252 lvth0=8.095441e-09 wvth0=-2.160999e-07
+ pvth0=2.28462e-14 k1=0.3710416 lk1=1.280615e-08 wk1=5.826215e-07 pk1=-4.385974e-13
+ k2=0.003697245 lk2=-3.620703e-09 wk2=-3.631068e-07 pk2=2.90273e-13 k3=0 dvt0=0
+ dvt1=0 dvt2=0 dvt0w=0 dvt1w=0 dvt2w=0 nlx=0 w0=0 k3b=0 vsat=250000 ua=1.199491e-09
+ lua=-5.134727e-16 wua=-6.6987e-15 pua=4.568244e-21 ub=1.98002e-18 lub=4.47024e-26
+ wub=-2.44001e-23 pub=2.172012e-29 uc=-2.839614e-11 luc=2.137661e-17 wuc=5.688399e-16
+ puc=-4.282227e-22 rdsw=900 prwb=0 prwg=0 wr=1 u0=0.01909702 lu0=-4.036052e-09
+ wu0=-2.332102e-08 pu0=1.75556e-14 a0=0.2084812 la0=8.119802e-08 wa0=-2.492375e-06
+ pa0=1.87626e-12 keta=0.0009144947 lketa=-2.411023e-08 wketa=-4.189654e-07 pketa=4.829833e-13
+ a1=0 a2=0.4 ags=0.02 b0=0 b1=0 voff=-0.1535852 lvoff=-4.829066e-09 wvoff=-1.283166e-06
+ pvoff=9.659671e-13 nfactor=7.413813 lnfactor=-4.022483e-06 wnfactor=-0.0001515203
+ pnfactor=1.140645e-10 cit=-0.004481022 lcit=3.110213e-09 wcit=1.168148e-07 pcit=-8.793822e-14
+ cdsc=0 cdscb=-3.846979e-05 lcdscb=6.995124e-11 wcdscb=6.166939e-09 pcdscb=-5.312816e-15
+ cdscd=0 eta0=0.0015488 leta0=1.142055e-09 weta0=-1.905851e-08 peta0=7.643801e-15
+ etab=-0.0001091449 letab=2.411023e-10 wetab=4.189654e-09 petab=-4.829833e-15 dsub=0
+ pclm=2.328059 lpclm=-4.14279e-07 wpclm=9.669695e-06 ppclm=-3.927623e-12 pdiblc1=1e-05
+ pdiblc2=0.0001 pdiblcb=0.02 drout=0 pscbe1=6.241878e+08 pscbe2=1e-20 pvag=0 delta=0.01
+ alpha0=8e-09 beta0=18 kt1=-0.5739956 lkt1=1.897084e-08 wkt1=1.943935e-06 pkt1=-1.463394e-12
+ kt2=-0.03736122 lkt2=-9.447099e-09 wkt2=-2.127518e-07 pkt2=3.273829e-13 at=1096581
+ lat=-0.8631461 wat=-22.96865 pat=1.72908e-05 ute=-2.111107 lute=1.152429e-08 wute=-9.512969e-06
+ pute=8.50673e-12 ua1=-3.03382e-09 lua1=5.448915e-16 wua1=1.449977e-14 pua1=-1.091543e-20
+ ub1=-1.249096e-18 lub1=8.554155e-25 wub1=1.56015e-23 pub1=-1.174481e-29 uc1=7.410578e-11
+ luc1=-8.037429e-17 wuc1=-2.527831e-15 puc1=1.902951e-21 kt1l=0 prt=0 js=0.0001
+ jsw=8.5e-12 cj=cjp cjsw=cjswp cjswg=cjswgp mj=0.6008857 mjsw=0.4471985 mjswg=0.4471985
+ pb=1.0864354 pbsw=1.0864354 pbswg=1.0864354 cta=9.168207e-4 ctp=1.441221e-3 pta=1.249266e-3
+ ptp=1.249266e-3 cgdo=cgop cgso=cgop xti=3 n=1 capmod=0 nqsmod=0 xpart=1 cf=0
+
//
//
     12: type=p minr=1e-60 lmin=3.5e-07 lmax=8.228e-07 - dxl wmin=19.9823e-06 - dxw wmax=0.0002001
+ tnom=25 version=3.1 tlev=1 tlevc=1 ldif=1.2e-07 hdif=hdifp rsh=153 rd=0
+ rs=0 tox=toxp xj=1e-07 nch=8.52e+16 lln=1 lwn=1 wln=1 wwn=1 lint=5e-08 ll=0 lw=0
+ lwl=0 wint=5e-08 wl=0 ww=0 wwl=0 mobmod=1 binunit=2 xl=3e-08 + dxl xw=1.5e-07
+ + dxw dwg=0 dwb=0 vth0=dvtp - 0.7626531 lvth0=1.240745e-08 wvth0=-2.807819e-07
+ pvth0=7.153884e-14 k1=0.3817151 lk1=4.771137e-09 wk1=-5.956208e-07 pk1=4.483834e-13
+ k2=0.01201855 lk2=-9.884982e-09 wk2=3.761379e-08 pk2=-1.138946e-14 k3=0 dvt0=0
+ dvt1=0 dvt2=0 dvt0w=0 dvt1w=0 dvt2w=0 nlx=0 w0=0 k3b=0 vsat=234765.8 lvsat=0.01146831
+ ua=6.60867e-10 lua=-1.079965e-16 wua=-3.657991e-15 pua=2.279199e-21 ub=1.547748e-18
+ lub=3.701174e-25 wub=1.277354e-23 pub=-6.2642e-30 uc=8.396441e-13 luc=-6.320841e-19
+ rdsw=900 prwb=0 prwg=0 wr=1 u0=0.01584556 lu0=-1.588356e-09 wu0=-1.023306e-12
+ pu0=3.097234e-19 a0=-0.1302253 la0=3.361762e-07 keta=-0.04330088 lketa=9.175107e-09
+ wketa=3.724136e-07 pketa=-1.127668e-13 a1=0 a2=0.4 ags=0.02476439 lags=-3.586633e-09
+ b0=0 b1=0 voff=-0.1936444 lvoff=2.532754e-08 nfactor=1.75984 lnfactor=2.338282e-07
+ cit=-0.0004139497 lcit=4.852149e-11 cdsc=0 cdscb=9.109151e-05 lcdscb=-2.758251e-11
+ wcdscb=-1.489654e-09 pcdscb=4.510674e-16 cdscd=0 eta0=-0.001554761 leta0=3.478416e-09
+ weta0=-1.489654e-08 peta0=4.510672e-15 etab=0.0003531954 letab=-1.069476e-10 wetab=-3.724136e-09
+ petab=1.127668e-15 dsub=0 pclm=2.230577 lpclm=-3.408944e-07 wpclm=7.448274e-06
+ ppclm=-2.255337e-12 pdiblc1=1e-05 pdiblc2=0.0001 pdiblcb=-0.05990778 lpdiblcb=6.015457e-08
+ drout=0 pscbe1=6.241878e+08 pscbe2=1e-20 pvag=0 delta=0.01 alpha0=8e-09 beta0=18
+ kt1=-0.5327772 lkt1=-1.205833e-08 kt2=-0.05792494 lkt2=6.033272e-09 wkt2=3.716073e-07
+ pkt2=-1.125227e-13 at=-90373.34 lat=0.03039305 ute=-2.310583 lute=1.616898e-07
+ wute=2.989703e-06 pute=-9.052822e-13 ua1=-3.117467e-09 lua1=6.078609e-16 ub1=1.015796e-18
+ lub1=-8.495951e-25 uc1=-3.445213e-11 luc1=1.348104e-18 kt1l=0 prt=0 js=0.0001
+ jsw=8.5e-12 cj=cjp cjsw=cjswp cjswg=cjswgp mj=0.6008857 mjsw=0.4471985 mjswg=0.4471985
+ pb=1.0864354 pbsw=1.0864354 pbswg=1.0864354 cta=9.168207e-4 ctp=1.441221e-3 pta=1.249266e-3
+ ptp=1.249266e-3 cgdo=cgop cgso=cgop xti=3 n=1 capmod=0 nqsmod=0 xpart=1 cf=0
+
//
//  *************************************************************
//                                                              *
//                                                              *
//              MODEL OF NORMAL NMOS WITH ESD IMPLANT           *
//                                                              *
//                                                              *
//                                                              *
//  *************************************************************
//
//
     }
model esd bsim3v3 type=n minr=1e-60 lmin=5e-07 lmax=2e-06 wmin=2e-05 wmax=0.0002
+ tnom=25 xl=4e-08 + dxl xw=1.5e-07 + dxw version=3.1 tox=toxe
+ xj=1e-07 nch=1.67e+17 lln=1 lwn=1 wln=1 wwn=1 lint=2.65e-08 wint=1.045e-08 mobmod=1
+ binunit=2 dwg=0 dwb=0 vth0=delvtoe + 0.528504 lvth0=1.600305e-08 wvth0=-1.163688e-07 pvth0=8.617066e-14
+ k1=0.6068993 lk1=6.56523e-11 wk1=5.794379e-08 pk1=-2.14663e-14 k2=0.003904743
+ lk2=-9.740818e-09 wk2=-4.423804e-08 pk2=8.785671e-14 k3=0 dvt0=0 dvt1=0 dvt2=0
+ dvt0w=0 dvt1w=0 dvt2w=0 nlx=0 w0=0 k3b=0 vsat=144113 lvsat=-0.02143011 wvsat=-0.8791328
+ pvsat=4.270828e-07 ua=-6.989363e-10 lua=3.839059e-16 wua=1.564043e-15 pua=-9.626974e-21
+ ub=2.79855e-18 lub=-7.489745e-25 wub=-1.011119e-23 pub=6.424319e-30 uc=9.638072e-11
+ luc=-3.040652e-17 wuc=-8.225216e-16 puc=-1.323798e-22 rdsw=843.02 prwb=0 prwg=0.09951968
+ lprwg=9.539158e-10 wprwg=9.600593e-08 pprwg=-1.906678e-13 wr=1.02 u0=0.03989203
+ lu0=3.075167e-09 wu0=-1.854298e-08 pu0=-8.748219e-14 a0=1.053599 la0=-3.5815e-07
+ wa0=-7.889827e-06 pa0=3.061187e-12 keta=-0.01584863 lketa=-3.929878e-09 wketa=-8.119118e-09
+ pketa=-6.336346e-15 a1=0 a2=0.2040602 la2=2.90161e-07 wa2=1.327406e-05 pa2=-6.579151e-12
+ ags=0.4268283 lags=-1.965929e-07 wags=-4.480015e-06 pags=2.563749e-14 b0=0 b1=0
+ voff=-0.15199 lvoff=3.893549e-08 wvoff=7.148623e-07 pvoff=-3.830064e-13 nfactor=1.198838
+ lnfactor=1.300779e-07 wnfactor=3.272877e-06 pnfactor=-7.965759e-12 cit=-8.689342e-05
+ lcit=-2.868235e-11 wcit=1.228284e-09 pcit=5.331741e-15 cdsc=0 cdscb=0 cdscd=1.435859e-05
+ lcdscd=-3.761988e-12 wcdscd=1.856062e-10 pcdscd=5.119275e-17 eta0=-1.56348e-05
+ leta0=7.294794e-10 weta0=1.105238e-08 peta0=-1.186431e-14 etab=6.158504e-05 letab=-1.223079e-10
+ wetab=3.142241e-10 petab=-6.240492e-16 dsub=0 pclm=0.01 pdiblc1=0 pdiblc2=0.001007836
+ lpdiblc2=2.392893e-09 wpdiblc2=-2.470551e-08 ppdiblc2=3.222406e-14 pdiblcb=0.03018186
+ lpdiblcb=-5.99412e-08 wpdiblcb=-8.575265e-07 ppdiblcb=1.703048e-12 drout=0 pscbe1=3.507054e+08
+ lpscbe1=18.08624 wpscbe1=1110.722 ppscbe1=0.001662824 pscbe2=9.522731e-06 lpscbe2=-4.412399e-12
+ wpscbe2=-9.450381e-11 ppscbe2=8.121755e-16 pvag=1 delta=0.007524362 ldelta=5.576452e-09
+ wdelta=-1.524273e-07 pdelta=1.708331e-13 alpha0=0 beta0=30 kt1=-0.3088121 lkt1=3.307732e-09
+ wkt1=6.325074e-07 pkt1=-4.04056e-13 kt2=-0.02727403 lkt2=-3.10482e-09 wkt2=-9.557799e-08
+ pkt2=8.556944e-14 at=142778.9 lat=-0.06783164 wat=-2.659813 pat=1.462047e-06 ute=-1.472504
+ lute=-1.287789e-07 wute=1.945827e-06 pute=3.112584e-12 ua1=2.153132e-09 lua1=-9.108532e-16
+ wua1=-3.782426e-15 pua1=1.366665e-20 ub1=-3.858063e-18 lub1=1.976238e-24 wub1=2.887845e-23
+ pub1=-2.441355e-29 uc1=-1.411095e-10 luc1=1.079735e-16 wuc1=1.135043e-15 puc1=-3.717429e-22
+ kt1l=0 prt=3.668969 lprt=-6.950868e-06 wprt=-8.820335e-05 pprt=1.497917e-10 cj=cje
+ mj=0.3075043 pb=0.6944474 cjsw=cjswe mjsw=0.1929617 pbsw=0.6944474 cjswg=cjswge
+ mjswg=0.1929617 pbswg=0.6944474 cta=0.001047197 ctp=0.000566277 pta=0.001820458
+ ptp=0.001820458 js=1e-06 jsw=2e-11 cgdo=cgoe cgso=cgoe cgbo=1e-13 capmod=0 nqsmod=0
+ xpart=1 cf=0 tlev=1 tlevc=1 xti=3 n=1 hdif=hdife ldif=1.2e-07 rsh=82.2 rs=0 rd=0
+ rsc=0 rdc=0
//
endsection mos
//
//  *************************************************************
//                                                              *
//                                                              *
//                  5V NORMAL DEVICES MODEL                     *
//                                                              *
//                                                              *
//                                                              *
//  *************************************************************
//
section mos_5v
//
//  *************************************************************
//                                                              *
//                  5V NMOS DEVICES MODEL                       *
//                                                              *
//  *************************************************************
//

//  *************************************************************
//                                                              *
//                   5V NORMAL DEVICES LIB                      *
//                                                              *
//  *************************************************************
//
model nch5 bsim3v3  {
     1: type=n minr=1e-60 lmin=1.4768e-06 - dxl5 lmax=2.01e-05 wmin=1.1866e-06 - dxw5 wmax=1.99866e-5
+ - dxw5 tnom=25 version=3.1 tlev=1 tlevc=1 ldif=1.2e-07 hdif=hdifn5 rsh=81.6
+ rd=0 rs=0 tox=toxn5 xj=1e-07 nch=8.521e+16 lln=1 lwn=1 wln=1 wwn=1 lint=4.5e-08
+ ll=0 lw=0 lwl=0 wint=6e-08 wl=0 ww=0 wwl=0 mobmod=1 binunit=2 xl=3e-08 + dxl5
+ xw=1.5e-07 + dxw5 dwg=0 dwb=0 vth0=dvtn5 + 0.7160501 lvth0=1.193414e-07 wvth0=-2.925136e-08
+ pvth0=-3.657939e-14 k1=0.8132342 lk1=-2.139212e-08 wk1=-2.121437e-07 pk1=3.090711e-13
+ k2=0.08275758 lk2=8.967889e-09 wk2=7.191232e-08 pk2=-1.167222e-13 k3=0 dvt0=0
+ dvt1=0 dvt2=0 dvt0w=0 dvt1w=0 dvt2w=0 nlx=0 w0=0 k3b=0 vsat=123421.3 lvsat=-0.05255322
+ wvsat=-0.05925493 pvsat=7.081954e-08 ua=-3.047443e-10 lua=-1.690591e-16 wua=1.232956e-15
+ pua=-1.236268e-21 ub=2.352611e-18 lub=-7.935409e-25 wub=-2.192591e-24 pub=2.144861e-30
+ uc=7.003104e-11 luc=-7.876901e-17 wuc=-1.025695e-16 puc=4.197229e-23 rdsw=1400
+ prwb=0 prwg=0 wr=1 u0=0.04513566 lu0=9.964791e-10 wu0=-2.613974e-09 pu0=-5.342892e-15
+ a0=0.8039786 la0=-1.062299e-07 wa0=2.28216e-07 pa0=-4.370248e-13 keta=0.02111606
+ lketa=-1.5376e-08 wketa=-2.614258e-09 pketa=-3.644901e-15 a1=0 a2=0.99 ags=0.03615667
+ lags=-1.097324e-07 wags=-1.592934e-08 pags=5.927313e-14 b0=0 b1=0 voff=-0.1728738
+ lvoff=2.866874e-08 wvoff=6.36742e-08 pvoff=-2.661858e-13 nfactor=1 cit=-0.0002232942
+ lcit=2.893404e-10 wcit=4.166176e-10 pcit=-8.160311e-16 cdsc=0 cdscb=0 cdscd=0
+ eta0=0.0001106705 leta0=5.836071e-10 weta0=7.453769e-11 peta0=5.196463e-16 etab=-7.636196e-06
+ letab=-7.285695e-11 wetab=1.400244e-11 petab=2.370925e-16 dsub=0 pclm=1.498093
+ lpclm=2.957647e-07 wpclm=-2.684087e-07 ppclm=1.860781e-13 pdiblc1=1e-05 pdiblc2=0.0002105483
+ lpdiblc2=-8.12005e-11 wpdiblc2=-1.34493e-10 ppdiblc2=9.878853e-17 pdiblcb=0.1144869
+ lpdiblcb=4.918969e-09 wpdiblcb=1.041207e-06 ppdiblcb=-9.846616e-14 drout=0 pscbe1=2.558995e+08
+ lpscbe1=262.2747 wpscbe1=126.2743 ppscbe1=-0.0004566628 pscbe2=5.811373e-06 lpscbe2=-2.103779e-12
+ wpscbe2=2.823782e-11 ppscbe2=-4.643062e-17 pvag=0.2425753 lpvag=7.897592e-07 wpvag=1.675947e-06
+ ppvag=-2.374482e-12 delta=0.02 alpha0=1.7171e-05 beta0=38.528 kt1=-0.4366094 lkt1=1.910069e-08
+ wkt1=2.357561e-09 pkt1=8.99589e-14 kt2=-0.04987791 lkt2=-2.665453e-09 wkt2=2.2954e-09
+ pkt2=5.149059e-14 at=259388.8 lat=-0.353334 wat=-0.2510155 pat=3.556388e-07 ute=-1.820306
+ lute=3.587164e-07 wute=2.540486e-07 pute=-1.580618e-13 ua1=-9.183781e-11 lua1=1.69318e-15
+ wua1=3.675379e-16 pua1=-6.124889e-22 ub1=1e-20 uc1=1.476667e-12 luc1=1.697575e-16
+ wuc1=1.984027e-18 puc1=-3.951542e-23 kt1l=0 prt=0 js=6.27496e-05 jsw=1.60291e-10
+ cj=cjn5 cjsw=cjswn5 cjswg=cjswgn5 mj=0.3771327 mjsw=0.1449861 mjswg=0.1449861
+ pb=0.8293711 pbsw=0.8293711 pbswg=0.8293711 cta=1.359e-3 ctp=1.4553e-3 pta=2.5416e-3
+ ptp=2.5416e-3 cgdo=cgon5 cgso=cgon5 xti=3 n=1 capmod=0 nqsmod=0 xpart=1 cf=0
+
//
//
     2: type=n minr=1e-60 lmin=7.768e-07 - dxl5 lmax=1.4768e-06 - dxl5 wmin=1.1866e-06 - dxw5
+ wmax=1.99866e-5 - dxw5 tnom=25 version=3.1 tlev=1 tlevc=1 ldif=1.2e-07
+ hdif=hdifn5 rsh=81.6 rd=0 rs=0 tox=toxn5 xj=1e-07 nch=8.521e+16 lln=1 lwn=1 wln=1
+ wwn=1 lint=4.5e-08 ll=0 lw=0 lwl=0 wint=6e-08 wl=0 ww=0 wwl=0 mobmod=1 binunit=2
+ xl=3e-08 + dxl5 xw=1.5e-07 + dxw5 dwg=0 dwb=0 vth0=dvtn5 + 0.7742557 lvth0=3.687584e-08
+ wvth0=-4.470767e-08 pvth0=-1.468088e-14 k1=0.7606325 lk1=5.313388e-08 wk1=5.162972e-08
+ pk1=-6.464309e-14 k2=0.108026 lk2=-2.683247e-08 wk2=-2.7284e-08 pk2=2.381914e-14
+ k3=0 dvt0=0 dvt1=0 dvt2=0 dvt0w=0 dvt1w=0 dvt2w=0 nlx=0 w0=0 k3b=0 vsat=97150.44
+ lvsat=-0.0153327 wvsat=-0.02368129 pvsat=2.04188e-08 ua=-3.654868e-10 lua=-8.299923e-17
+ wua=2.891078e-16 pua=1.009768e-22 ub=2.092632e-18 lub=-4.252023e-25 wub=-1.453934e-25
+ pub=-7.556084e-31 uc=6.154675e-11 luc=-6.674847e-17 wuc=-7.54463e-17 puc=3.54412e-24
+ rdsw=1400 prwb=0 prwg=0 wr=1 u0=0.04112792 lu0=6.674643e-09 wu0=-2.522283e-09
+ pu0=-5.4728e-15 a0=0.9753814 la0=-3.490734e-07 wa0=-3.799908e-07 pa0=4.246826e-13
+ keta=0.03413409 lketa=-3.381995e-08 wketa=-3.286184e-08 pketa=3.920987e-14 a1=0
+ a2=0.99 ags=-0.06356966 lags=3.15598e-08 wags=1.028388e-07 pags=-1.089975e-13
+ b0=0 b1=0 voff=-0.207608 lvoff=7.788018e-08 wvoff=-1.819084e-07 pvoff=8.175564e-14
+ nfactor=1 cit=-0.0004690668 lcit=6.37551e-10 wcit=4.13028e-10 pcit=-8.109454e-16
+ cdsc=0 cdscb=0 cdscd=0 eta0=0.0002280999 leta0=4.172331e-10 weta0=5.879402e-10
+ peta0=-2.077425e-16 etab=0.0001467451 letab=-2.915844e-10 wetab=-1.920416e-11
+ petab=2.841397e-16 dsub=0 pclm=1.077091 lpclm=8.922393e-07 wpclm=2.482068e-07
+ ppclm=-5.458628e-13 pdiblc1=1e-05 pdiblc2=0.0002077489 lpdiblc2=-7.723444e-11
+ wpdiblc2=-1.310873e-10 ppdiblc2=9.396341e-17 pdiblcb=0.1722942 lpdiblcb=-7.698244e-08
+ wpdiblcb=9.056039e-07 ppdiblcb=9.365683e-14 drout=0 pscbe1=4.797392e+08 lpscbe1=-54.8615
+ wpscbe1=-345.1526 ppscbe1=0.000211255 pscbe2=6.995522e-06 lpscbe2=-3.781479e-12
+ wpscbe2=-8.382039e-12 ppscbe2=5.452395e-18 pvag=1.108201 lpvag=-4.366592e-07 wpvag=3.725216e-07
+ ppvag=-5.277886e-13 delta=0.02 alpha0=1.7171e-05 beta0=38.528 kt1=-0.3700218 lkt1=-7.52407e-08
+ wkt1=1.243145e-09 pkt1=9.153783e-14 kt2=-0.04264374 lkt2=-1.291483e-08 wkt2=2.817127e-08
+ pkt2=1.482966e-14 at=-6022.654 lat=0.0227009 wat=0.01326417 pat=-1.879268e-08
+ ute=-1.415707 lute=-2.145197e-07 wute=-1.867375e-08 pute=2.283313e-13 ua1=6.989369e-10
+ lua1=5.728105e-16 wua1=-1.708799e-16 pua1=1.503414e-22 ub1=1e-20 uc1=5.587832e-11
+ luc1=9.268131e-17 wuc1=5.367844e-17 puc1=-1.127561e-22 kt1l=0 prt=0 js=6.27496e-05
+ jsw=1.60291e-10 cj=cjn5 cjsw=cjswn5 cjswg=cjswgn5 mj=0.3771327 mjsw=0.1449861
+ mjswg=0.1449861 pb=0.8293711 pbsw=0.8293711 pbswg=0.8293711 cta=1.359e-3 ctp=1.4553e-3
+ pta=2.5416e-3 ptp=2.5416e-3 cgdo=cgon5 cgso=cgon5 xti=3 n=1 capmod=0 nqsmod=0
+ xpart=1 cf=0
//
//
     3: type=n minr=1e-60 lmin=5e-07 lmax=7.768e-07 - dxl5 wmin=1.1866e-06 - dxw5 wmax=1.99866e-5
+ - dxw5 tnom=25 version=3.1 tlev=1 tlevc=1 ldif=1.2e-07 hdif=hdifn5 rsh=81.6
+ rd=0 rs=0 tox=toxn5 xj=1e-07 nch=8.521e+16 lln=1 lwn=1 wln=1 wwn=1 lint=4.5e-08
+ ll=0 lw=0 lwl=0 wint=6e-08 wl=0 ww=0 wwl=0 mobmod=1 binunit=2 xl=3e-08 + dxl5
+ xw=1.5e-07 + dxw5 dwg=0 dwb=0 vth0=dvtn5 + 0.8816147 lvth0=-4.007912e-08 wvth0=-1.357187e-07
+ pvth0=5.055582e-14 k1=0.8786767 lk1=-3.148016e-08 wk1=1.437095e-09 pk1=-2.866503e-14
+ k2=0.1318776 lk2=-4.392925e-08 wk2=2.511806e-09 pk2=2.461502e-15 k3=0 dvt0=0 dvt1=0
+ dvt2=0 dvt0w=0 dvt1w=0 dvt2w=0 nlx=0 w0=0 k3b=0 vsat=77382.76 lvsat=-0.001163218
+ wvsat=0.007570815 pvsat=-1.982707e-09 ua=-1.164636e-09 lua=4.898312e-16 wua=1.043561e-15
+ pua=-4.398154e-22 ub=3.581349e-18 lub=-1.492314e-24 wub=-3.118039e-24 pub=1.375184e-30
+ uc=1.016678e-10 luc=-9.550721e-17 wuc=-9.826651e-17 puc=1.990164e-23 rdsw=1400
+ prwb=0 prwg=0 wr=1 u0=0.0376413 lu0=9.173854e-09 wu0=-6.315261e-09 pu0=-2.753993e-15
+ a0=1.331732 la0=-6.045051e-07 wa0=-1.003761e-08 pa0=1.595002e-13 keta=0.01221691
+ lketa=-1.810972e-08 wketa=-4.289826e-10 pketa=1.5962e-14 a1=0 a2=0.99 ags=-0.07807274
+ lags=4.195561e-08 wags=-4.562323e-08 pags=-2.579971e-15 b0=0 b1=0 voff=-0.1008694
+ lvoff=1.369923e-09 wvoff=-1.61013e-07 pvoff=6.677785e-14 nfactor=1 cit=0.0001247854
+ lcit=2.118778e-10 wcit=-2.125891e-09 pcit=1.008952e-15 cdsc=0 cdscb=0 cdscd=0
+ eta0=-0.00351763 leta0=3.102172e-09 weta0=7.265092e-10 peta0=-3.07069e-16 etab=0.0009769659
+ letab=-8.866866e-10 wetab=-1.981018e-10 petab=4.123735e-16 dsub=0 pclm=2.472318
+ lpclm=-1.078595e-07 wpclm=-9.879333e-07 ppclm=3.402023e-13 pdiblc1=1e-05 pdiblc2=0.0001
+ pdiblcb=-0.2848955 lpdiblcb=2.507312e-07 wpdiblcb=2.475979e-06 ppdiblcb=-1.031988e-12
+ drout=0 pscbe1=3.337439e+08 lpscbe1=49.78798 wpscbe1=-31.59911 ppscbe1=-1.350022e-05
+ pscbe2=1.389228e-06 lpscbe2=2.371121e-13 wpscbe2=-2.366666e-13 ppscbe2=-3.862086e-19
+ pvag=1.167242 lpvag=-4.789795e-07 wpvag=-9.232066e-07 ppvag=4.009893e-13 delta=0.02
+ alpha0=1.7171e-05 beta0=38.528 kt1=-0.5308903 lkt1=4.006981e-08 wkt1=2.054071e-07
+ pkt1=-5.480687e-14 kt2=-0.1298553 lkt2=4.959838e-08 wkt2=1.406478e-07 pkt2=-6.579349e-14
+ at=17940.48 lat=0.005524126 wat=-0.02555081 pat=9.029897e-09 ute=-1.586968 lute=-9.175968e-08
+ wute=6.436011e-07 pute=-2.463873e-13 ua1=8.171159e-10 lua1=4.880997e-16 wua1=1.154639e-15
+ pua1=-7.997908e-22 ub1=1e-20 uc1=2.591391e-10 luc1=-5.301601e-17 wuc1=-1.936086e-16
+ puc1=6.449927e-23 kt1l=0 prt=0 js=6.27496e-05 jsw=1.60291e-10 cj=cjn5 cjsw=cjswn5
+ cjswg=cjswgn5 mj=0.3771327 mjsw=0.1449861 mjswg=0.1449861 pb=0.8293711 pbsw=0.8293711
+ pbswg=0.8293711 cta=1.359e-3 ctp=1.4553e-3 pta=2.5416e-3 ptp=2.5416e-3 cgdo=cgon5
+ cgso=cgon5 xti=3 n=1 capmod=0 nqsmod=0 xpart=1 cf=0
+
//
//
     4: type=n minr=1e-60 lmin=1.4768e-06 - dxl5 lmax=2.01e-05 wmin=7.866e-07 - dxw5 wmax=1.1866e-06
+ - dxw5 tnom=25 version=3.1 tlev=1 tlevc=1 ldif=1.2e-07 hdif=hdifn5 rsh=81.6
+ rd=0 rs=0 tox=toxn5 xj=1e-07 nch=8.521e+16 lln=1 lwn=1 wln=1 wwn=1 lint=4.5e-08
+ ll=0 lw=0 lwl=0 wint=6e-08 wl=0 ww=0 wwl=0 mobmod=1 binunit=2 xl=3e-08 + dxl5
+ xw=1.5e-07 + dxw5 dwg=0 dwb=0 vth0=dvtn5 + 0.716976 lvth0=7.130424e-08 wvth0=-3.037783e-08
+ pvth0=2.186268e-14 k1=0.34655 lk1=4.248781e-07 wk1=3.556242e-07 pk1=-2.338612e-13
+ k2=0.2549874 lk2=-1.562995e-07 wk2=-1.376224e-07 pk2=8.434208e-14 k3=0 dvt0=0
+ dvt1=0 dvt2=0 dvt0w=0 dvt1w=0 dvt2w=0 nlx=0 w0=0 k3b=0 vsat=63928.49 lvsat=0.01720822
+ wvsat=0.01312399 pvsat=-1.405223e-08 ua=5.652651e-10 lua=-1.795517e-15 wua=1.745027e-16
+ pua=7.424808e-22 ub=1.895503e-19 lub=3.726479e-24 wub=4.389887e-25 pub=-3.354195e-30
+ uc=-2.907984e-11 luc=1.082396e-16 wuc=1.800878e-17 puc=-1.855424e-22 rdsw=1400
+ prwb=0 prwg=0 wr=1 u0=0.04299843 lu0=-1.015954e-08 wu0=-1.382523e-11 pu0=8.229521e-15
+ a0=1.117108 la0=-1.165744e-06 wa0=-1.527375e-07 pa0=8.519803e-13 keta=0.01123998
+ lketa=-1.320881e-08 wketa=9.400973e-09 pketa=-6.281518e-15 a1=0 a2=0.99 ags=0.008902191
+ lags=-1.855685e-07 wags=1.722848e-08 pags=1.515352e-13 b0=0 b1=0 voff=0.005775839
+ lvoff=-6.797976e-07 wvoff=-1.536709e-07 pvoff=5.957343e-13 nfactor=1 cit=-0.000375391
+ lcit=-4.049137e-10 wcit=6.016586e-10 pcit=2.859847e-17 cdsc=0 cdscb=0 cdscd=0
+ eta0=4.703133e-05 leta0=2.13069e-09 weta0=1.51961e-10 peta0=-1.362534e-15 etab=-2.431403e-05
+ letab=4.801238e-10 wetab=3.429267e-11 petab=-4.356639e-16 dsub=0 pclm=0.4085876
+ lpclm=2.675253e-06 wpclm=1.057083e-06 ppclm=-2.708807e-12 pdiblc1=1e-05 pdiblc2=0.0001
+ pdiblcb=2.634791 lpdiblcb=-6.987976e-07 wpdiblcb=-2.024994e-06 ppdiblcb=7.576754e-13
+ drout=0 pscbe1=4.807397e+08 lpscbe1=-614.8711 wpscbe1=-147.2663 ppscbe1=0.0006104726
+ pscbe2=5.893929e-05 lpscbe2=-8.721632e-11 wpscbe2=-3.63976e-11 ppscbe2=5.711729e-17
+ pvag=4.598141 lpvag=-3.07018e-06 wpvag=-3.623034e-06 ppvag=2.32152e-12 delta=0.02
+ alpha0=1.7171e-05 beta0=38.528 kt1=-0.4424202 lkt1=2.880304e-07 wkt1=9.426929e-09
+ pkt1=-2.372209e-13 kt2=-0.001672706 lkt2=9.298603e-08 wkt2=-5.635105e-08 pkt2=-6.487899e-14
+ at=53063.35 lat=-0.06101216 ute=-2.033218 lute=4.962802e-07 wute=5.130771e-07
+ pute=-3.254217e-13 ua1=-7.493567e-10 lua1=1.232709e-15 wua1=1.167475e-15 pua1=-5.227951e-23
+ ub1=1e-20 uc1=2.470978e-11 luc1=1.095636e-16 wuc1=-2.628139e-17 puc1=3.371659e-23
+ kt1l=0 prt=0 js=6.27496e-05 jsw=1.60291e-10 cj=cjn5 cjsw=cjswn5 cjswg=cjswgn5
+ mj=0.3771327 mjsw=0.1449861 mjswg=0.1449861 pb=0.8293711 pbsw=0.8293711 pbswg=0.8293711
+ cta=1.359e-3 ctp=1.4553e-3 pta=2.5416e-3 ptp=2.5416e-3 cgdo=cgon5 cgso=cgon5 xti=3
+ n=1 capmod=0 nqsmod=0 xpart=1 cf=0
+
//
//
     5: type=n minr=1e-60 lmin=7.768e-07 - dxl5 lmax=1.4768e-06 - dxl5 wmin=7.866e-07 - dxw5
+ wmax=1.1866e-06 - dxw5 tnom=25 version=3.1 tlev=1 tlevc=1 ldif=1.2e-07
+ hdif=hdifn5 rsh=81.6 rd=0 rs=0 tox=toxn5 xj=1e-07 nch=8.521e+16 lln=1 lwn=1 wln=1
+ wwn=1 lint=4.5e-08 ll=0 lw=0 lwl=0 wint=6e-08 wl=0 ww=0 wwl=0 mobmod=1 binunit=2
+ xl=3e-08 + dxl5 xw=1.5e-07 + dxw5 dwg=0 dwb=0 vth0=dvtn5 + 0.757386 lvth0=1.405136e-08
+ wvth0=-2.418408e-08 pvth0=1.308738e-14 k1=0.4186933 lk1=3.226654e-07 wk1=4.676329e-07
+ pk1=-3.92555e-13 k2=0.2501783 lk2=-1.494861e-07 wk2=-2.002264e-07 pk2=1.730395e-13
+ k3=0 dvt0=0 dvt1=0 dvt2=0 dvt0w=0 dvt1w=0 dvt2w=0 nlx=0 w0=0 k3b=0 vsat=76289.56
+ lvsat=-0.0003049522 wvsat=0.001698046 pvsat=2.136052e-09 ua=-9.995526e-10 lua=4.215168e-16
+ wua=1.060512e-15 pua=-5.128172e-22 ub=4.329603e-18 lub=-2.139147e-24 wub=-2.866892e-24
+ pub=1.329576e-30 uc=1.424847e-10 luc=-1.34833e-16 wuc=-1.739154e-16 puc=8.637577e-23
+ rdsw=1400 prwb=0 prwg=0 wr=1 u0=0.04192219 lu0=-8.634713e-09 wu0=-3.488586e-09
+ pu0=1.315256e-14 a0=-0.1736086 la0=6.629432e-07 wa0=1.01787e-06 pa0=-8.065365e-13
+ keta=-0.005120256 lketa=9.970379e-09 wketa=1.489499e-08 pketa=-1.406544e-14 a1=0
+ a2=0.99 ags=-0.01840011 lags=-1.468866e-07 wags=4.788552e-08 pags=1.081003e-13
+ b0=0 b1=0 voff=-0.7284026 lvoff=3.603864e-07 wvoff=4.516902e-07 pvoff=-2.619414e-13
+ nfactor=1 cit=-0.0006371906 lcit=-3.399597e-11 wcit=6.175676e-10 pcit=6.058589e-18
+ cdsc=0 cdscb=0 cdscd=0 eta0=0.001105242 leta0=6.314169e-10 weta0=-4.791907e-10
+ peta0=-4.683184e-16 etab=6.285548e-05 letab=3.566221e-10 wetab=8.285589e-11 petab=-5.044682e-16
+ dsub=0 pclm=2.496856 lpclm=-2.834049e-07 wpclm=-1.479078e-06 ppclm=8.844256e-13
+ pdiblc1=1e-05 pdiblc2=0.0001 pdiblcb=2.141568 wpdiblcb=-1.490214e-06 drout=0 pscbe1=-1.944705e+08
+ lpscbe1=341.7668 wpscbe1=475.0909 ppscbe1=-0.000271283 pscbe2=-5.433933e-06 lpscbe2=3.987667e-12
+ wpscbe2=6.739634e-12 ppscbe2=-3.999548e-18 pvag=4.506817 lpvag=-2.940791e-06 wpvag=-3.762234e-06
+ ppvag=2.518738e-12 delta=0.02 alpha0=1.7171e-05 beta0=38.528 kt1=-0.1774013 lkt1=-8.744845e-08
+ wkt1=-2.33099e-07 pkt1=1.063898e-13 kt2=0.1126152 lkt2=-6.893709e-08 wkt2=-1.607167e-07
+ pkt2=8.298633e-14 at=25784.97 lat=-0.02236414 wat=-0.02543298 pat=3.603344e-08
+ ute=-2.292395 lute=8.634823e-07 wute=1.047905e-06 pute=-1.083166e-12 ua1=-2.263129e-09
+ lua1=3.377421e-15 wua1=3.432769e-15 pua1=-3.261747e-21 ub1=1e-20 uc1=2.086569e-10
+ luc1=-1.510526e-16 wuc1=-1.321919e-16 puc1=1.837706e-22 kt1l=0 prt=0 js=6.27496e-05
+ jsw=1.60291e-10 cj=cjn5 cjsw=cjswn5 cjswg=cjswgn5 mj=0.3771327 mjsw=0.1449861
+ mjswg=0.1449861 pb=0.8293711 pbsw=0.8293711 pbswg=0.8293711 cta=1.359e-3 ctp=1.4553e-3
+ pta=2.5416e-3 ptp=2.5416e-3 cgdo=cgon5 cgso=cgon5 xti=3 n=1 capmod=0 nqsmod=0
+ xpart=1 cf=0
//
//
     6: type=n minr=1e-60 lmin=5e-07 lmax=7.768e-07 - dxl5 wmin=7.866e-07 - dxw5 wmax=1.1866e-06
+ - dxw5 tnom=25 version=3.1 tlev=1 tlevc=1 ldif=1.2e-07 hdif=hdifn5 rsh=81.6
+ rd=0 rs=0 tox=toxn5 xj=1e-07 nch=8.521e+16 lln=1 lwn=1 wln=1 wwn=1 lint=4.5e-08
+ ll=0 lw=0 lwl=0 wint=6e-08 wl=0 ww=0 wwl=0 mobmod=1 binunit=2 xl=3e-08 + dxl5
+ xw=1.5e-07 + dxw5 dwg=0 dwb=0 vth0=dvtn5 + 0.754185 lvth0=1.634588e-08 wvth0=1.93123e-08
+ pvth0=-1.809083e-14 k1=1.310955 lk1=-3.169078e-07 wk1=-5.244728e-07 pk1=3.185861e-13
+ k2=-0.004792294 lk2=3.327685e-08 wk2=1.687844e-07 pk2=-9.146744e-14 k3=0 dvt0=0
+ dvt1=0 dvt2=0 dvt0w=0 dvt1w=0 dvt2w=0 nlx=0 w0=0 k3b=0 vsat=128261.1 lvsat=-0.03755817
+ wvsat=-0.05432782 pvsat=4.229539e-08 ua=-3.472056e-09 lua=2.193807e-15 wua=3.850767e-15
+ pua=-2.512872e-21 ub=2.864159e-18 lub=-1.088717e-24 wub=-2.245506e-24 pub=8.841667e-31
+ uc=-2.594599e-11 luc=-1.410189e-17 wuc=5.698841e-17 puc=-7.913607e-23 rdsw=1400
+ prwb=0 prwg=0 wr=1 u0=0.001911031 lu0=2.004528e-08 wu0=3.715418e-08 pu0=-1.598017e-14
+ a0=4.16018 la0=-2.443516e-06 wa0=-3.451127e-06 pa0=2.39684e-12 keta=0.08663055
+ lketa=-5.579659e-08 wketa=-9.096062e-08 pketa=6.181185e-14 a1=0 a2=0.99 ags=-0.3923464
+ lags=1.211581e-07 wags=3.367221e-07 pags=-9.89377e-14 b0=0 b1=0 voff=-0.4380599
+ lvoff=1.522687e-07 wvoff=2.492129e-07 pvoff=-1.168056e-13 nfactor=1 cit=-0.003066113
+ lcit=1.707055e-09 wcit=1.756155e-09 pcit=-8.100807e-16 cdsc=0 cdscb=0 cdscd=0
+ eta0=0.001225382 leta0=5.453e-10 weta0=-5.043839e-09 peta0=2.803621e-15 etab=0.00203359
+ letab=-1.056e-09 wetab=-1.483591e-09 petab=6.183606e-16 dsub=0 pclm=2.270198 lpclm=-1.209366e-07
+ wpclm=-7.420332e-07 ppclm=3.561119e-13 pdiblc1=1e-05 pdiblc2=0.0001 pdiblcb=4.251054
+ lpdiblcb=-1.51208e-06 wpdiblcb=-3.042457e-06 ppdiblcb=1.112647e-12 drout=0 pscbe1=2.581153e+08
+ lpscbe1=17.35328 wpscbe1=60.4106 ppscbe1=2.595983e-05 pscbe2=-5.215625e-07 lpscbe2=4.664796e-13
+ wpscbe2=2.088001e-12 ppscbe2=-6.652571e-19 pvag=0.7827297 lpvag=-2.713658e-07
+ wpvag=-4.554094e-07 ppvag=1.484066e-13 delta=0.02 alpha0=1.7171e-05 beta0=38.528
+ kt1=-0.257047 lkt1=-3.035837e-08 wkt1=-1.277506e-07 pkt1=3.087606e-14 kt2=0.05983669
+ lkt2=-3.110545e-08 wkt2=-9.013142e-08 pkt2=3.239077e-14 at=-46166.95 lat=0.02921099
+ wat=0.05244228 pat=-1.978754e-08 ute=1.026002 lute=-1.515144e-06 wute=-2.535337e-06
+ pute=1.485302e-12 ua1=8.612783e-09 lua1=-4.418432e-15 wua1=-8.329568e-15 pua1=5.169495e-21
+ ub1=1e-20 uc1=4.23374e-10 luc1=-3.049618e-16 wuc1=-3.934167e-16 puc1=3.710164e-22
+ kt1l=0 prt=0 js=6.27496e-05 jsw=1.60291e-10 cj=cjn5 cjsw=cjswn5 cjswg=cjswgn5
+ mj=0.3771327 mjsw=0.1449861 mjswg=0.1449861 pb=0.8293711 pbsw=0.8293711 pbswg=0.8293711
+ cta=1.359e-3 ctp=1.4553e-3 pta=2.5416e-3 ptp=2.5416e-3 cgdo=cgon5 cgso=cgon5 xti=3
+ n=1 capmod=0 nqsmod=0 xpart=1 cf=0
+
//
//
     7: type=n minr=1e-60 lmin=1.4768e-06 - dxl5 lmax=2.01e-05 wmin=4e-07 wmax=7.866e-07 -
+ dxw5 tnom=25 version=3.1 tlev=1 tlevc=1 ldif=1.2e-07 hdif=hdifn5 rsh=81.6
+ rd=0 rs=0 tox=toxn5 xj=1e-07 nch=8.521e+16 lln=1 lwn=1 wln=1 wwn=1 lint=4.5e-08
+ ll=0 lw=0 lwl=0 wint=6e-08 wl=0 ww=0 wwl=0 mobmod=1 binunit=2 xl=3e-08 + dxl5
+ xw=1.5e-07 + dxw5 dwg=0 dwb=0 vth0=dvtn5 + 0.7276775 lvth0=1.104379e-07 wvth0=-3.911664e-08
+ pvth0=-1.009389e-14 k1=0.8510062 lk1=2.169435e-07 wk1=-5.63147e-08 pk1=-6.406188e-14
+ k2=0.04890428 lk2=-7.47679e-08 wk2=3.066504e-08 pk2=1.776336e-14 k3=0 dvt0=0 dvt1=0
+ dvt2=0 dvt0w=0 dvt1w=0 dvt2w=0 nlx=0 w0=0 k3b=0 vsat=113839.4 lvsat=-0.05167251
+ wvsat=-0.02763327 pvsat=4.219578e-08 ua=2.32315e-10 lua=4.079006e-17 wua=4.463897e-16
+ pua=-7.570474e-22 ub=1.293545e-18 lub=-1.10585e-24 wub=-4.625334e-25 pub=5.918851e-31
+ uc=-5.49437e-12 luc=-1.071675e-16 wuc=-1.251108e-18 puc=-9.640929e-24 rdsw=1400
+ prwb=0 prwg=0 wr=1 u0=0.04138438 lu0=7.996047e-10 wu0=1.304215e-09 pu0=-7.19717e-16
+ a0=0.9677507 la0=-3.549583e-08 wa0=-3.07721e-08 pa0=-7.098053e-14 keta=0.02698686
+ lketa=-1.8047e-08 wketa=-3.457925e-09 pketa=-2.330647e-15 a1=0 a2=0.99 ags=0.040415
+ wags=-8.504888e-09 b0=0 b1=0 voff=-0.2188311 lvoff=6.215273e-08 wvoff=2.974309e-08
+ pvoff=-1.014232e-14 nfactor=1 cit=0.000464038 lcit=-5.521448e-10 wcit=-8.381916e-11
+ pcit=1.488275e-16 cdsc=0 cdscb=0 cdscd=0 eta0=0.0004112525 leta0=-1.497303e-10
+ weta0=-1.45462e-10 peta0=4.996568e-16 etab=4.746675e-05 letab=-1.2805e-10 wetab=-2.432351e-11
+ petab=6.097093e-17 dsub=0 pclm=2.175756 lpclm=-1.326279e-06 wpclm=-3.859872e-07
+ ppclm=5.588441e-13 pdiblc1=1e-05 pdiblc2=0.0001 pdiblcb=0.1430265 lpdiblcb=4.675931e-07
+ wpdiblcb=9.780725e-09 ppdiblcb=-1.947993e-13 drout=0 pscbe1=2.952797e+08 lpscbe1=320.4201
+ wpscbe1=4.180377 ppscbe1=-0.0001532861 pscbe2=1.761226e-05 lpscbe2=-1.96731e-11
+ wpscbe2=-2.649951e-12 ppscbe2=1.961496e-18 pvag=0.2987112 lpvag=-6.726488e-07
+ wpvag=-1.121194e-07 ppvag=3.63696e-13 delta=0.02 alpha0=1.7171e-05 beta0=38.528
+ kt1=-0.3702644 lkt1=-5.461356e-08 wkt1=-4.949553e-08 pkt1=4.258212e-14 kt2=-0.0690529
+ lkt2=1.574866e-08 wkt2=-1.328377e-09 pkt2=-1.806951e-15 at=19425.49 lat=-0.01335404
+ wat=0.02746868 pat=-3.891762e-08 ute=-1.37406 lute=-2.054924e-07 wute=-2.519133e-08
+ pute=2.476457e-13 ua1=1.395157e-09 lua1=-3.52877e-16 wua1=-5.837347e-16 pua1=1.24251e-21
+ ub1=1.003988e-20 lub1=-7.943019e-28 wub1=-3.256683e-29 pub1=6.486269e-34 uc1=-1.051866e-11
+ luc1=6.130762e-18 wuc1=2.486163e-18 puc1=1.181798e-22 kt1l=0 prt=0 js=6.27496e-05
+ jsw=1.60291e-10 cj=cjn5 cjsw=cjswn5 cjswg=cjswgn5 mj=0.3771327 mjsw=0.1449861
+ mjswg=0.1449861 pb=0.8293711 pbsw=0.8293711 pbswg=0.8293711 cta=1.359e-3 ctp=1.4553e-3
+ pta=2.5416e-3 ptp=2.5416e-3 cgdo=cgon5 cgso=cgon5 xti=3 n=1 capmod=0 nqsmod=0
+ xpart=1 cf=0
//
//
     8: type=n minr=1e-60 lmin=7.768e-07 - dxl5 lmax=1.4768e-06 - dxl5 wmin=4e-07 wmax=7.866e-07
+ - dxw5 tnom=25 version=3.1 tlev=1 tlevc=1 ldif=1.2e-07 hdif=hdifn5 rsh=81.6
+ rd=0 rs=0 tox=toxn5 xj=1e-07 nch=8.521e+16 lln=1 lwn=1 wln=1 wwn=1 lint=4.5e-08
+ ll=0 lw=0 lwl=0 wint=6e-08 wl=0 ww=0 wwl=0 mobmod=1 binunit=2 xl=3e-08 + dxl5
+ xw=1.5e-07 + dxw5 dwg=0 dwb=0 vth0=dvtn5 + 0.8013124 lvth0=6.111921e-09 wvth0=-6.00544e-08
+ pvth0=1.957073e-14 k1=1.285213 lk1=-3.98241e-07 wk1=-2.399673e-07 pk1=1.961371e-13
+ k2=-0.1138082 lk2=1.557631e-07 wk2=9.700493e-08 pk2=-7.6227e-14 k3=0 dvt0=0 dvt1=0
+ dvt2=0 dvt0w=0 dvt1w=0 dvt2w=0 nlx=0 w0=0 k3b=0 vsat=74606.2 lvsat=0.003913108
+ wvsat=0.003072686 pvsat=-1.308417e-09 ua=-3.262286e-10 lua=8.321349e-16 wua=5.106758e-16
+ pua=-8.48128e-22 ub=9.340716e-19 lub=-5.965479e-25 wub=-9.410095e-26 pub=6.989007e-32
+ uc=-1.238161e-10 luc=6.047078e-17 wuc=4.354589e-17 puc=-7.310933e-23 rdsw=1400
+ prwb=0 prwg=0 wr=1 u0=0.03237708 lu0=1.356114e-08 wu0=4.305953e-09 pu0=-4.972578e-15
+ a0=1.105779 la0=-2.310551e-07 wa0=-2.687808e-08 pa0=-7.649759e-14 keta=0.02267514
+ lketa=-1.193815e-08 wketa=-7.802726e-09 pketa=3.825065e-15 a1=0 a2=0.99 ags=0.06131995
+ lags=-2.961814e-08 wags=-1.721389e-08 pags=1.233892e-14 b0=0 b1=0 voff=-0.2260368
+ lvoff=7.23618e-08 wvoff=4.145836e-08 pvoff=-2.674053e-14 nfactor=1 cit=0.0002170056
+ lcit=-2.021496e-10 wcit=-7.996917e-11 pcit=1.433728e-16 cdsc=0 cdscb=0 cdscd=0
+ eta0=0.001350041 leta0=-1.479806e-09 weta0=-6.790936e-10 peta0=1.255706e-15 etab=0.0003952329
+ letab=-6.207652e-10 wetab=-1.885635e-10 petab=2.936662e-16 dsub=0 pclm=0.7088658
+ lpclm=7.520114e-07 wpclm=-1.900562e-08 ppclm=3.890463e-14 pdiblc1=1e-05 pdiblc2=0.0001
+ pdiblcb=0.6332092 lpdiblcb=-2.26898e-07 wpdiblcb=-2.584887e-07 ppdiblcb=1.852849e-13
+ drout=0 pscbe1=5.607857e+08 lpscbe1=-55.74886 wpscbe1=-141.6514 ppscbe1=5.332833e-05
+ pscbe2=4.963393e-06 lpscbe2=-1.752178e-12 wpscbe2=-1.750823e-12 ppscbe2=6.876093e-19
+ pvag=-0.4587352 lpvag=4.005014e-07 wpvag=2.926361e-07 ppvag=-2.097616e-13 delta=0.02
+ alpha0=1.7171e-05 beta0=38.528 kt1=-0.3505789 lkt1=-8.250393e-08 wkt1=-9.168211e-08
+ pkt1=1.023521e-13 kt2=-0.07817478 lkt2=2.867252e-08 wkt2=-4.917643e-09 pkt2=3.278322e-15
+ at=-10692.47 lat=0.0293171 wat=0.004354501 pat=-6.169458e-09 ute=-0.8306929 lute=-9.753351e-07
+ wute=-1.457213e-07 pute=4.184127e-13 ua1=2.7572e-09 lua1=-2.282619e-15 wua1=-6.668318e-16
+ pua1=1.360242e-21 ub1=-1.23839e-20 lub1=3.097572e-26 wub1=1.82787e-26 pub1=-2.529478e-32
+ uc1=-6.157209e-12 luc1=-4.858668e-20 wuc1=4.322526e-17 puc1=6.046069e-23 kt1l=0
+ prt=0 js=6.27496e-05 jsw=1.60291e-10 cj=cjn5 cjsw=cjswn5 cjswg=cjswgn5 mj=0.3771327
+ mjsw=0.1449861 mjswg=0.1449861 pb=0.8293711 pbsw=0.8293711 pbswg=0.8293711 cta=1.359e-3
+ ctp=1.4553e-3 pta=2.5416e-3 ptp=2.5416e-3 cgdo=cgon5 cgso=cgon5 xti=3 n=1 capmod=0
+ nqsmod=0 xpart=1 cf=0
//
//
     9: type=n minr=1e-60 lmin=5e-07 lmax=7.768e-07 - dxl5 wmin=4e-07 wmax=7.866e-07 - dxw5
+ tnom=25 version=3.1 tlev=1 tlevc=1 ldif=1.2e-07 hdif=hdifn5 rsh=81.6 rd=0
+ rs=0 tox=toxn5 xj=1e-07 nch=8.521e+16 lln=1 lwn=1 wln=1 wwn=1 lint=4.5e-08 ll=0
+ lw=0 lwl=0 wint=6e-08 wl=0 ww=0 wwl=0 mobmod=1 binunit=2 xl=3e-08 + dxl5 xw=1.5e-07
+ + dxw5 dwg=0 dwb=0 vth0=dvtn5 + 0.801025 lvth0=6.317962e-09 wvth0=-1.893728e-08
+ pvth0=-9.902023e-15 k1=0.5422925 lk1=1.342845e-07 wk1=1.032171e-07 pk1=-4.985744e-14
+ k2=0.2610573 lk2=-1.129404e-07 wk2=-4.830839e-08 pk2=2.793358e-14 k3=0 dvt0=0
+ dvt1=0 dvt2=0 dvt0w=0 dvt1w=0 dvt2w=0 nlx=0 w0=0 k3b=0 vsat=56894.82 lvsat=0.01660862
+ wvsat=0.003949918 pvsat=-1.937215e-09 ua=2.048742e-09 lua=-8.702442e-16 wua=-6.575166e-16
+ pua=-1.076766e-23 ub=-2.657071e-20 lub=9.204046e-26 wub=1.150644e-25 pub=-8.003962e-32
+ uc=1.094896e-10 luc=-1.067628e-16 wuc=-5.36083e-17 puc=-3.469208e-24 rdsw=1400
+ prwb=0 prwg=0 wr=1 u0=0.05079535 lu0=3.589268e-10 wu0=-2.764758e-09 pu0=9.570658e-17
+ a0=-0.4819689 la0=9.070427e-07 wa0=3.396512e-07 pa0=-3.392257e-13 keta=-0.02710977
+ lketa=2.374767e-08 wketa=1.91973e-09 pketa=-3.14399e-15 a1=0 a2=0.99 ags=-0.04005479
+ lags=4.304726e-08 wags=4.904073e-08 pags=-3.515238e-14 b0=0 b1=0 voff=-0.1513954
+ lvoff=1.885885e-08 wvoff=1.512268e-08 pvoff=-7.863109e-15 nfactor=1 cit=-0.002083355
+ lcit=1.446749e-09 wcit=9.536349e-10 pcit=-5.975145e-16 cdsc=0 cdscb=0 cdscd=0
+ eta0=-0.007208975 leta0=4.655297e-09 weta0=1.843658e-09 peta0=-5.526021e-16 etab=-0.001153704
+ letab=4.895123e-10 wetab=1.119153e-09 petab=-6.437049e-16 dsub=0 pclm=1.100534
+ lpclm=4.71264e-07 wpclm=2.131145e-07 ppclm=-1.27479e-13 pdiblc1=1e-05 pdiblc2=0.0001
+ pdiblcb=0.5252922 lpdiblcb=-1.49543e-07 drout=0 pscbe1=5.433444e+08 lpscbe1=-43.24691
+ wpscbe1=-172.5074 ppscbe1=7.544593e-05 pscbe2=5.509004e-06 lpscbe2=-2.143271e-12
+ wpscbe2=-2.836559e-12 ppscbe2=1.465865e-18 pvag=0.1396675 lpvag=-2.84337e-08 wpvag=6.971517e-08
+ ppvag=-4.997183e-14 delta=0.02 alpha0=1.7171e-05 beta0=38.528 kt1=-0.4333648 lkt1=-2.316299e-08
+ wkt1=1.623052e-08 pkt1=2.500031e-14 kt2=-0.02811505 lkt2=-7.210284e-09 wkt2=-1.831002e-08
+ pkt2=1.287798e-14 at=30495.79 lat=-0.0002066445 wat=-0.01016051 pat=4.2349e-09
+ ute=-3.073816 lute=6.325351e-07 wute=8.125732e-07 pute=-2.684927e-13 ua1=-4.870528e-09
+ lua1=3.184935e-15 wua1=2.680903e-15 pua1=-1.039414e-21 ub1=5.976984e-20 lub1=-2.074407e-26
+ wub1=-4.064204e-26 pub1=1.69396e-32 uc1=-4.316739e-10 luc1=3.049616e-16 wuc1=3.048153e-16
+ puc1=-1.27047e-22 kt1l=0 prt=0 js=6.27496e-05 jsw=1.60291e-10 cj=cjn5 cjsw=cjswn5
+ cjswg=cjswgn5 mj=0.3771327 mjsw=0.1449861 mjswg=0.1449861 pb=0.8293711 pbsw=0.8293711
+ pbswg=0.8293711 cta=1.359e-3 ctp=1.4553e-3 pta=2.5416e-3 ptp=2.5416e-3 cgdo=cgon5
+ cgso=cgon5 xti=3 n=1 capmod=0 nqsmod=0 xpart=1 cf=0
+
//
//
     10: type=n minr=1e-60 lmin=1.4768e-06 - dxl5 lmax=2.01e-05 wmin=1.99866e-5 - dxw5 wmax=0.0002001
+ tnom=25 version=3.1 tlev=1 tlevc=1 ldif=1.2e-07 hdif=hdifn5 rsh=81.6 rd=0
+ rs=0 tox=toxn5 xj=1e-07 nch=8.521e+16 lln=1 lwn=1 wln=1 wwn=1 lint=4.5e-08 ll=0
+ lw=0 lwl=0 wint=6e-08 wl=0 ww=0 wwl=0 mobmod=1 binunit=2 xl=3e-08 + dxl5 xw=1.5e-07
+ + dxw5 dwg=0 dwb=0 vth0=dvtn5 + 0.7120259 lvth0=1.242937e-07 wvth0=5.129949e-08
+ pvth0=-1.357066e-13 k1=0.8026358 lk1=-5.9514e-09 k2=0.08635022 lk2=3.13662e-09
+ k3=0 dvt0=0 dvt1=0 dvt2=0 dvt0w=0 dvt1w=0 dvt2w=0 nlx=0 w0=0 k3b=0 vsat=120486.5
+ lvsat=-0.04952366 wvsat=-0.0005110129 pvsat=1.017798e-08 ua=-2.454454e-10 lua=-1.850583e-16
+ wua=4.599222e-17 pua=-9.160173e-22 ub=2.268603e-18 lub=-1.194864e-24 wub=-5.110249e-25
+ pub=1.017798e-29 uc=6.573998e-11 luc=-9.326611e-17 wuc=-1.667719e-17 puc=3.321548e-22
+ rdsw=1400 prwb=0 prwg=0 wr=1 u0=0.04500507 lu0=7.295559e-10 a0=0.7803909 la0=1.261754e-07
+ wa0=7.003621e-07 pa0=-5.088987e-12 keta=0.01423347 lketa=-1.386974e-08 wketa=1.351519e-07
+ pketa=-3.379531e-14 a1=0 a2=0.99 ags=0.03536087 lags=-1.067713e-07 b0=0 b1=0 voff=-0.2128542
+ lvoff=7.652159e-08 wvoff=8.63945e-07 pvoff=-1.224037e-12 nfactor=1 cit=-0.0005622225
+ lcit=7.739986e-10 wcit=7.200812e-09 pcit=-1.051724e-14 cdsc=0 cdscb=0 cdscd=0
+ eta0=9.644974e-05 leta0=6.349917e-10 weta0=3.591888e-10 peta0=-5.088987e-16 etab=-6.93665e-06
+ letab=-6.101215e-11 dsub=0 pclm=1.245423 lpclm=6.440455e-07 wpclm=4.789186e-06
+ ppclm=-6.785319e-12 pdiblc1=1e-05 pdiblc2=0.0002038292 lpdiblc2=-7.626517e-11
+ pdiblcb=0.166504 drout=0 pscbe1=2.6391e+08 lpscbe1=205.5621 wpscbe1=-34.06823
+ ppscbe1=0.0006785317 pscbe2=7.188053e-06 lpscbe2=-3.745412e-12 wpscbe2=6.81363e-13
+ ppscbe2=-1.357065e-17 pvag=0.3263032 lpvag=6.711337e-07 delta=0.02 alpha0=1.7171e-05
+ beta0=38.528 kt1=-0.4364917 lkt1=2.35949e-08 kt2=-0.04976324 lkt2=-9.305739e-11
+ at=246848.4 lat=-0.3355669 ute=-1.807614 lute=3.508199e-07 ua1=-7.77068e-11 lua1=1.857497e-15
+ wua1=8.468363e-17 pua1=-3.901561e-21 ub1=1e-20 uc1=3.277788e-12 luc1=1.33885e-16
+ wuc1=-3.406835e-17 puc1=6.785315e-22 kt1l=0 prt=0 js=6.27496e-05 jsw=1.60291e-10
+ cj=cjn5 cjsw=cjswn5 cjswg=cjswgn5 mj=0.3771327 mjsw=0.1449861 mjswg=0.1449861
+ pb=0.8293711 pbsw=0.8293711 pbswg=0.8293711 cta=1.359e-3 ctp=1.4553e-3 pta=2.5416e-3
+ ptp=2.5416e-3 cgdo=cgon5 cgso=cgon5 xti=3 n=1 capmod=0 nqsmod=0 xpart=1 cf=0
+
//
//
     11: type=n minr=1e-60 lmin=7.768e-07 - dxl5 lmax=1.4768e-06 - dxl5 wmin=1.99866e-5 - dxw5
+ wmax=0.0002001 tnom=25 version=3.1 tlev=1 tlevc=1 ldif=1.2e-07 hdif=hdifn5
+ rsh=81.6 rd=0 rs=0 tox=toxn5 xj=1e-07 nch=8.521e+16 lln=1 lwn=1 wln=1 wwn=1 lint=4.5e-08
+ ll=0 lw=0 lwl=0 wint=6e-08 wl=0 ww=0 wwl=0 mobmod=1 binunit=2 xl=3e-08 + dxl5
+ xw=1.5e-07 + dxw5 dwg=0 dwb=0 vth0=dvtn5 + 0.7765203 lvth0=3.291817e-08 wvth0=-9.003649e-08
+ pvth0=6.453816e-14 k1=0.7632119 lk1=4.990441e-08 k2=0.106663 lk2=-2.56425e-08
+ k3=0 dvt0=0 dvt1=0 dvt2=0 dvt0w=0 dvt1w=0 dvt2w=0 nlx=0 w0=0 k3b=0 vsat=95292.64
+ lvsat=-0.01382896 wvsat=0.01350563 pvsat=-9.680849e-09 ua=-1.537738e-10 lua=-3.149386e-16
+ wua=-3.948666e-15 pua=4.743615e-21 ub=1.410646e-18 lub=2.068977e-26 wub=1.350565e-23
+ pub=-9.680849e-30 uc=3.575822e-11 luc=-5.078794e-17 wuc=4.407524e-16 puc=-3.159313e-22
+ rdsw=1400 prwb=0 prwg=0 wr=1 u0=0.04100191 lu0=6.40123e-09 a0=1.123611 la0=-3.600996e-07
+ wa0=-3.347052e-06 pa0=6.453893e-13 keta=0.02123828 lketa=-2.379417e-08 wketa=2.252684e-07
+ pketa=-1.614723e-13 a1=0 a2=0.99 ags=-0.058432 lags=2.611446e-08 b0=0 b1=0 voff=-0.2166959
+ lvoff=8.196456e-08 nfactor=1 cit=-0.0004259418 lcit=5.80916e-10 wcit=-4.501877e-10
+ pcit=3.226946e-16 cdsc=0 cdscb=0 cdscd=0 eta0=0.00028023 leta0=3.746118e-10 weta0=-4.555276e-10
+ peta0=6.453911e-16 etab=0.0001457857 letab=-2.773892e-10 dsub=0 pclm=0.959296
+ lpclm=1.049429e-06 wpclm=2.606065e-06 ppclm=-3.692274e-12 pdiblc1=1e-05 pdiblc2=0.0002012
+ lpdiblc2=-7.254017e-11 pdiblcb=0.2175369 lpdiblcb=-7.230354e-08 drout=0 pscbe1=4.175145e+08
+ lpscbe1=-12.06479 wpscbe1=900.3766 ppscbe1=-0.00064539 pscbe2=7.476399e-06 lpscbe2=-4.153942e-12
+ wpscbe2=-1.800755e-11 ppscbe2=1.290781e-17 pvag=1.126812 lpvag=-4.630267e-07 delta=0.02
+ alpha0=1.7171e-05 beta0=38.528 kt1=-0.3699597 lkt1=-7.066761e-08 kt2=-0.04123634
+ lkt2=-1.217397e-08 at=-5360 lat=0.02176205 ute=-1.359746 lute=-2.837194e-07 wute=-1.138815e-06
+ pute=1.613473e-12 ua1=9.60289e-10 lua1=3.868649e-16 wua1=-5.402261e-15 pua1=3.87234e-21
+ ub1=1e-20 uc1=1.357851e-11 luc1=1.192909e-16 wuc1=9.003762e-16 puc1=-6.453898e-22
+ kt1l=0 prt=0 js=6.27496e-05 jsw=1.60291e-10 cj=cjn5 cjsw=cjswn5 cjswg=cjswgn5
+ mj=0.3771327 mjsw=0.1449861 mjswg=0.1449861 pb=0.8293711 pbsw=0.8293711 pbswg=0.8293711
+ cta=1.359e-3 ctp=1.4553e-3 pta=2.5416e-3 ptp=2.5416e-3 cgdo=cgon5 cgso=cgon5 xti=3
+ n=1 capmod=0 nqsmod=0 xpart=1 cf=0
+
//
//
     12: type=n minr=1e-60 lmin=5e-07 lmax=7.768e-07 - dxl5 wmin=1.99866e-5 - dxw5 wmax=0.0002001
+ tnom=25 version=3.1 tlev=1 tlevc=1 ldif=1.2e-07 hdif=hdifn5 rsh=81.6 rd=0
+ rs=0 tox=toxn5 xj=1e-07 nch=8.521e+16 lln=1 lwn=1 wln=1 wwn=1 lint=4.5e-08 ll=0
+ lw=0 lwl=0 wint=6e-08 wl=0 ww=0 wwl=0 mobmod=1 binunit=2 xl=3e-08 + dxl5 xw=1.5e-07
+ + dxw5 dwg=0 dwb=0 vth0=dvtn5 + 0.9030557 lvth0=-5.778245e-08 wvth0=-5.648943e-07
+ pvth0=4.049162e-13 k1=0.9096258 lk1=-5.504504e-08 wk1=-6.180575e-07 pk1=4.430237e-13
+ k2=0.1320031 lk2=-4.380628e-08 k3=0 dvt0=0 dvt1=0 dvt2=0 dvt0w=0 dvt1w=0 dvt2w=0
+ nlx=0 w0=0 k3b=0 vsat=78841.66 lvsat=-0.002036904 wvsat=-0.02163158 pvsat=1.550552e-08
+ ua=-8.753265e-10 lua=2.022703e-16 wua=-4.747443e-15 pua=5.316178e-21 ub=3.439471e-18
+ lub=-1.433572e-24 wub=-2.781197e-25 pub=1.993567e-31 uc=2.202651e-10 luc=-1.830425e-16
+ wuc=-2.472181e-15 puc=1.77206e-21 rdsw=1400 prwb=0 prwg=0 wr=1 u0=0.0326943 lu0=1.235612e-08
+ wu0=9.270681e-08 pu0=-6.645223e-14 a0=1.623284 la0=-7.182648e-07 wa0=-5.845926e-06
+ pa0=2.436582e-12 keta=0.01219548 lketa=-1.731228e-08 a1=0 a2=0.99 ags=-0.08035202
+ lags=4.182672e-08 b0=0 b1=0 voff=-0.1089134 lvoff=4.706042e-09 nfactor=1 cit=1.857912e-05
+ lcit=2.622834e-10 cdsc=0 cdscb=0 cdscd=0 eta0=-0.003534435 leta0=3.108963e-09
+ weta0=1.062894e-09 peta0=-4.430131e-16 etab=0.0009670691 letab=-8.66085e-10 dsub=0
+ pclm=2.726752 lpclm=-2.174828e-07 wpclm=-6.080822e-06 ppclm=2.534487e-12 pdiblc1=1e-05
+ pdiblc2=0.0001 pdiblcb=-0.1611993 lpdiblcb=1.991746e-07 drout=0 pscbe1=3.321652e+08
+ lpscbe1=49.11353 pscbe2=1.377405e-06 lpscbe2=2.178177e-13 pvag=1.12112 lpvag=-4.589467e-07
+ delta=0.02 alpha0=1.7171e-05 beta0=38.528 kt1=-0.5206285 lkt1=3.733175e-08 kt2=-0.1228287
+ lkt2=4.631143e-08 at=10488.67 lat=0.01040172 wat=0.1236091 pat=-8.860297e-08 ute=-1.532411
+ lute=-1.599531e-07 wute=-4.484412e-07 pute=1.118613e-12 ua1=-3.602656e-10 lua1=1.333438e-15
+ wua1=2.472181e-14 pua1=-1.772059e-20 ub1=1e-20 uc1=4.87685e-11 luc1=9.406671e-17
+ wuc1=4.017295e-15 puc1=-2.879597e-21 kt1l=0 prt=0 js=6.27496e-05 jsw=1.60291e-10
+ cj=cjn5 cjsw=cjswn5 cjswg=cjswgn5 mj=0.3771327 mjsw=0.1449861 mjswg=0.1449861
+ pb=0.8293711 pbsw=0.8293711 pbswg=0.8293711 cta=1.359e-3 ctp=1.4553e-3 pta=2.5416e-3
+ ptp=2.5416e-3 cgdo=cgon5 cgso=cgon5 xti=3 n=1 capmod=0 nqsmod=0 xpart=1 cf=0
+
//
//
//  *************************************************************
//                                                              *
//                  5V PMOS DEVICES MODEL                       *
//                                                              *
//  *************************************************************
//
     }
model pch5 bsim3v3  {
     1: type=p minr=1e-60 lmin=1.5145e-06 - dxl5 lmax=2.01e-5 wmin=1.1804e-06 - dxw5 wmax=1.99804e-05
+ - dxw5 tnom=25 version=3.1 tlev=1 tlevc=1 ldif=1.2e-07 hdif=hdifp5 rsh=153
+ rd=0 rs=0 tox=toxp5 xj=1e-07 nch=4.3968e+16 lln=1 lwn=1 wln=1 wwn=1 lint=4e-08
+ ll=0 lw=0 lwl=0 wint=4e-08 wl=0 ww=0 wwl=0 mobmod=1 binunit=2 xl=3e-08 + dxl5
+ xw=1.5e-07 + dxw5 dwg=0 dwb=0 vth0=dvtp5 - 1.01743 lvth0=-6.58148e-08 wvth0=-1.028983e-07
+ pvth0=9.108871e-14 k1=0.5868915 lk1=-5.522057e-08 wk1=8.656731e-08 pk1=-2.830925e-13
+ k2=0.02409285 lk2=7.699812e-09 wk2=-1.609027e-09 pk2=8.009042e-14 k3=0 dvt0=0
+ dvt1=0 dvt2=0 dvt0w=0 dvt1w=0 dvt2w=0 nlx=0 w0=0 k3b=0 vsat=175000 ua=3.012839e-09
+ lua=-7.001454e-16 wua=-1.736934e-15 pua=9.921333e-22 ub=2.259061e-19 lub=9.282935e-25
+ wub=1.303256e-26 pub=-1.243839e-30 uc=-6.306287e-11 luc=-3.62901e-18 wuc=-6.907448e-17
+ puc=5.156255e-24 rdsw=1200 prwb=0 prwg=0 wr=1 u0=0.02274138 lu0=-5.1246e-09 wu0=-9.820416e-09
+ pu0=2.399724e-15 a0=0.6885419 la0=-3.563784e-08 wa0=4.127144e-08 pa0=6.784013e-13
+ keta=0.008611895 lketa=-8.354743e-09 wketa=5.76849e-09 pketa=1.256345e-14 a1=0
+ a2=0.4120113 la2=-1.75906e-08 wa2=-2.408324e-07 pa2=3.52699e-13 ags=0.02133021
+ wags=-2.66713e-08 b0=0 b1=0 voff=-0.1507676 lvoff=1.367832e-08 wvoff=-8.865081e-08
+ pvoff=4.373965e-14 nfactor=2.564515 lnfactor=-1.871363e-06 wnfactor=-1.866307e-06
+ pnfactor=3.123807e-12 cit=-0.0004320731 lcit=6.894969e-11 wcit=2.197202e-09 pcit=-1.987243e-15
+ cdsc=0 cdscb=0 cdscd=0 eta0=0.0003150895 leta0=1.303525e-09 weta0=-2.868963e-10
+ peta0=7.953889e-16 etab=-7.177569e-23 letab=1.051154e-28 wetab=1.439132e-27 petab=-2.107609e-33
+ dsub=0 pclm=2.72689 lpclm=8.868492e-07 wpclm=-1.027345e-07 ppclm=1.650042e-13
+ pdiblc1=1e-05 pdiblc2=5e-05 pdiblcb=0.1538261 lpdiblcb=2.531067e-07 wpdiblcb=1.585232e-08
+ ppdiblcb=-3.164845e-13 drout=0 pscbe1=3.983654e+08 lpscbe1=148.8438 wpscbe1=-79.16951
+ ppscbe1=0.0001159437 pscbe2=4.129196e-06 lpscbe2=-1.892077e-13 wpscbe2=-2.590438e-12
+ ppscbe2=3.793697e-18 pvag=0 delta=0.01030478 ldelta=-4.463555e-10 wdelta=-6.111046e-09
+ pdelta=8.949626e-15 alpha0=1.5e-06 beta0=38.1 kt1=-0.5452737 lkt1=-7.328091e-08
+ wkt1=2.313836e-08 pkt1=5.078059e-14 kt2=-0.0589422 lkt2=4.147233e-08 wkt2=-3.060147e-09
+ pkt2=-4.473898e-14 at=4644.425 lat=-0.006757243 wat=-0.0006145891 pat=5.880231e-09
+ ute=-1.423584 lute=-4.47635e-07 wute=5.004158e-07 pute=4.194145e-13 ua1=-6.598179e-10
+ lua1=-1.097188e-15 wua1=3.344704e-15 pua1=-8.165371e-22 ub1=-1.147026e-18 lub1=-2.014639e-24
+ wub1=-3.465708e-24 pub1=4.317704e-30 uc1=-5.10609e-11 luc1=-1.794797e-17 wuc1=-4.40652e-17
+ puc1=1.031208e-22 kt1l=0 prt=0 js=0.0001 jsw=2.42572e-11 pb=1.236234 mj=0.6625574
+ mjsw=0.4851755 pbsw=1.236234 pbswg=1.236234 cj=cjp5 cjsw=cjswp5 cjswg=cjswgp5
+ cgdo=cgop5 cgso=cgop5 cta=1.377674e-3 ctp=4.878735e-4 pta=2.163191e-3 ptp=2.163191e-3
+ mjswg=0.4851755 xti=3 n=1 capmod=0 nqsmod=0 xpart=1 cf=0
+
//
//
     2: type=p minr=1e-60 lmin=8.145e-07 - dxl5 lmax=1.5145e-06 - dxl5 wmin=1.1804e-06 - dxw5
+ wmax=1.99804e-05 - dxw5 tnom=25 version=3.1 tlev=1 tlevc=1 ldif=1.2e-07
+ hdif=hdifp5 rsh=153 rd=0 rs=0 tox=toxp5 xj=1e-07 nch=4.3968e+16 lln=1 lwn=1 wln=1
+ wwn=1 lint=4e-08 ll=0 lw=0 lwl=0 wint=4e-08 wl=0 ww=0 wwl=0 mobmod=1 binunit=2
+ xl=3e-08 + dxl5 xw=1.5e-07 + dxw5 dwg=0 dwb=0 vth0=dvtp5 - 1.065191 lvth0=4.131871e-09
+ wvth0=-2.637065e-08 pvth0=-2.098608e-14 k1=0.5679547 lk1=-2.748778e-08 wk1=-4.416883e-07
+ pk1=4.905379e-13 k2=0.02415008 lk2=7.616014e-09 wk2=1.525662e-07 pk2=-1.456992e-13
+ k3=0 dvt0=0 dvt1=0 dvt2=0 dvt0w=0 dvt1w=0 dvt2w=0 nlx=0 w0=0 k3b=0 vsat=169539.3
+ lvsat=0.007997217 ua=2.836888e-09 lua=-4.424651e-16 wua=-2.050503e-15 pua=1.451355e-21
+ ub=5.677195e-19 lub=4.277076e-25 wub=-7.120744e-25 pub=-1.819195e-31 uc=-7.428062e-11
+ luc=1.279936e-17 wuc=-1.21928e-16 puc=8.256031e-23 rdsw=1200 prwb=0 prwg=0 wr=1
+ u0=0.02205643 lu0=-4.121497e-09 wu0=-1.109931e-08 pu0=4.272668e-15 a0=0.3312353
+ la0=4.876377e-07 wa0=1.277385e-06 pa0=-1.131888e-12 keta=0.001164958 lketa=2.551297e-09
+ wketa=2.844879e-08 pketa=-2.065185e-14 a1=0 a2=0.4 ags=0.06617814 lags=-6.567981e-08
+ wags=-4.997438e-08 pags=3.412738e-14 b0=0 b1=0 voff=-0.1471531 lvoff=8.384814e-09
+ wvoff=-2.030862e-08 pvoff=-5.634749e-14 nfactor=1.352073 lnfactor=-9.574182e-08
+ wnfactor=-1.044086e-06 pnfactor=1.919665e-12 cit=-0.0004427892 lcit=8.464354e-11
+ wcit=1.087327e-09 pcit=-3.618311e-16 cdsc=0 cdscb=0 cdscd=0 eta0=-0.0004445641
+ leta0=2.416038e-09 weta0=1.554751e-09 peta0=-1.901703e-15 etab=0.0005404234 letab=-7.914502e-10
+ wetab=-6.531976e-10 petab=9.56608e-16 dsub=0 pclm=3.649409 lpclm=-4.641794e-07
+ wpclm=-1.929068e-07 ppclm=2.970617e-13 pdiblc1=1e-05 pdiblc2=5e-05 pdiblcb=0.3948266
+ lpdiblcb=-9.983864e-08 wpdiblcb=-4.905593e-07 ppdiblcb=4.251554e-13 drout=0 pscbe1=4.808313e+08
+ lpscbe1=28.07252 wpscbe1=0.9510477 ppscbe1=-1.392807e-06 pscbe2=5.091391e-06 lpscbe2=-1.598342e-12
+ wpscbe2=-2.039021e-13 ppscbe2=2.986148e-19 pvag=0 delta=0.01 alpha0=1.5e-06 beta0=38.1
+ kt1=-0.651789 lkt1=8.271075e-08 wkt1=1.296754e-07 pkt1=-1.052429e-13 kt2=-0.03489918
+ lkt2=6.261347e-09 wkt2=-3.284913e-08 pkt2=-1.113014e-15 at=-2256.74 lat=0.003349516
+ wat=0.009842439 pat=-9.434088e-09 ute=-1.843992 lute=1.680518e-07 wute=7.664132e-07
+ pute=2.986133e-14 ua1=-1.855336e-09 lua1=6.536486e-16 wua1=3.633999e-15 pua1=-1.24021e-21
+ ub1=-2.313158e-18 lub1=-3.068375e-25 wub1=-2.495357e-24 pub1=2.896625e-30 uc1=-2.869531e-11
+ luc1=-5.070237e-17 wuc1=4.403499e-18 puc1=3.213845e-23 kt1l=0 prt=0 js=0.0001
+ jsw=2.42572e-11 pb=1.236234 mj=0.6625574 mjsw=0.4851755 pbsw=1.236234 pbswg=1.236234
+ cj=cjp5 cjsw=cjswp5 cjswg=cjswgp5 cgdo=cgop5 cgso=cgop5 cta=1.377674e-3 ctp=4.878735e-4
+ pta=2.163191e-3 ptp=2.163191e-3 mjswg=0.4851755 xti=3 n=1 capmod=0 nqsmod=0 xpart=1
+ cf=0
//
//
     3: type=p minr=1e-60 lmin=5e-07 lmax=8.145e-07 - dxl5 wmin=1.1804e-06 - dxw5 wmax=1.99804e-05
+ - dxw5 tnom=25 version=3.1 tlev=1 tlevc=1 ldif=1.2e-07 hdif=hdifp5 rsh=153
+ rd=0 rs=0 tox=toxp5 xj=1e-07 nch=4.3968e+16 lln=1 lwn=1 wln=1 wwn=1 lint=4e-08
+ ll=0 lw=0 lwl=0 wint=4e-08 wl=0 ww=0 wwl=0 mobmod=1 binunit=2 xl=3e-08 + dxl5
+ xw=1.5e-07 + dxw5 dwg=0 dwb=0 vth0=dvtp5 - 1.091464 lvth0=2.421732e-08 wvth0=-8.679404e-08
+ pvth0=2.520761e-14 k1=0.4638654 lk1=5.208846e-08 wk1=6.023579e-07 pk1=-3.076354e-13
+ k2=0.04872319 lk2=-1.117013e-08 wk2=-1.246207e-07 pk2=6.62102e-14 k3=0 dvt0=0
+ dvt1=0 dvt2=0 dvt0w=0 dvt1w=0 dvt2w=0 nlx=0 w0=0 k3b=0 vsat=179485.1 lvsat=0.0003936442
+ wvsat=0.01032402 pvsat=-7.89271e-09 ua=2.030989e-09 lua=1.736449e-16 wua=1.350387e-15
+ pua=-1.148626e-21 ub=9.130971e-19 lub=1.636665e-25 wub=-1.399626e-24 pub=3.437136e-31
+ uc=-6.625377e-11 luc=6.662843e-18 wuc=8.841018e-17 puc=-7.824326e-23 rdsw=1200
+ prwb=0 prwg=0 wr=1 u0=0.01828747 lu0=-1.240127e-09 wu0=-2.575862e-09 pu0=-2.24351e-15
+ a0=0.4159315 la0=4.228875e-07 wa0=-7.724485e-07 pa0=4.352104e-13 keta=0.01095301
+ lketa=-4.931666e-09 wketa=-3.126646e-08 pketa=2.500046e-14 a1=0 a2=0.4758901 la2=-5.801796e-08
+ wa2=1.858323e-07 pa2=-1.420688e-13 ags=-0.01932203 lags=-3.149152e-10 wags=-1.359347e-08
+ pags=6.314169e-15 b0=0 b1=0 voff=-0.1262129 lvoff=-7.623908e-09 wvoff=5.473556e-09
+ pvoff=-7.605796e-14 nfactor=1.62955 lnfactor=-3.078729e-07 wnfactor=2.705804e-06
+ pnfactor=-9.471254e-13 cit=-0.0004200856 lcit=6.728657e-11 wcit=1.110909e-09 pcit=-3.79859e-16
+ cdsc=0 cdscb=0 cdscd=0 eta0=-0.002021108 leta0=3.621305e-09 weta0=-2.314012e-09
+ peta0=1.055966e-15 etab=2.765247e-05 letab=-3.994368e-10 wetab=6.202276e-10 petab=-1.692563e-17
+ dsub=0 pclm=3.787691 lpclm=-5.69896e-07 wpclm=8.412852e-08 ppclm=8.52682e-14 pdiblc1=9.967614e-06
+ lpdiblc1=2.475819e-14 wpdiblc1=6.493273e-13 ppdiblc1=-4.964107e-19 pdiblc2=4.887538e-05
+ lpdiblc2=8.597742e-13 wpdiblc2=2.254911e-11 ppdiblc2=-1.72388e-17 pdiblcb=0.3289984
+ lpdiblcb=-4.951296e-08 wpdiblcb=-1.53872e-08 ppdiblcb=6.188629e-14 drout=0 pscbe1=6.8578e+08
+ lpscbe1=-128.6108 wpscbe1=-90.69588 ppscbe1=6.867127e-05 pscbe2=6.745792e-06 lpscbe2=-2.863132e-12
+ wpscbe2=-2.105688e-13 ppscbe2=3.037114e-19 pvag=0 delta=0.01 alpha0=1.5e-06 beta0=38.1
+ kt1=-0.438899 lkt1=-8.004362e-08 wkt1=-1.830154e-07 pkt1=1.338093e-13 kt2=-0.0196842
+ lkt2=-5.370511e-09 wkt2=-7.022525e-08 pkt2=2.746103e-14 at=1798.382 lat=0.0002493745
+ wat=-0.007444003 pat=3.781397e-09 ute=-0.8807635 lute=-5.683361e-07 wute=-5.864107e-07
+ pute=1.064095e-12 ua1=2.858233e-09 lua1=-2.949875e-15 wua1=-7.055729e-15 pua1=6.932087e-21
+ ub1=-4.434422e-18 lub1=1.314869e-24 wub1=1.03217e-23 pub1=-6.902017e-30 uc1=-1.412041e-10
+ luc1=3.531059e-17 wuc1=1.715727e-16 puc1=-9.566242e-23 kt1l=0 prt=0 js=0.0001
+ jsw=2.42572e-11 pb=1.236234 mj=0.6625574 mjsw=0.4851755 pbsw=1.236234 pbswg=1.236234
+ cj=cjp5 cjsw=cjswp5 cjswg=cjswgp5 cgdo=cgop5 cgso=cgop5 cta=1.377674e-3 ctp=4.878735e-4
+ pta=2.163191e-3 ptp=2.163191e-3 mjswg=0.4851755 xti=3 n=1 capmod=0 nqsmod=0 xpart=1
+ cf=0
//
//
     4: type=p minr=1e-60 lmin=1.5145e-06 - dxl5 lmax=2.01e-05 wmin=7.804e-07 - dxw5 wmax=1.1804e-06
+ - dxw5 tnom=25 version=3.1 tlev=1 tlevc=1 ldif=1.2e-07 hdif=hdifp5 rsh=153
+ rd=0 rs=0 tox=toxp5 xj=1e-07 nch=4.3968e+16 lln=1 lwn=1 wln=1 wwn=1 lint=4e-08
+ ll=0 lw=0 lwl=0 wint=4e-08 wl=0 ww=0 wwl=0 mobmod=1 binunit=2 xl=3e-08 + dxl5
+ xw=1.5e-07 + dxw5 dwg=0 dwb=0 vth0=dvtp5 - 1.103757 lvth0=1.779547e-08 wvth0=5.044761e-09
+ pvth0=-1.345756e-14 k1=0.7060764 lk1=-1.036255e-06 wk1=-6.246133e-08 pk1=9.435926e-13
+ k2=0.03507507 lk2=2.215405e-07 wk2=-1.534122e-08 pk2=-1.87296e-13 k3=0 dvt0=0
+ dvt1=0 dvt2=0 dvt0w=0 dvt1w=0 dvt2w=0 nlx=0 w0=0 k3b=0 vsat=188154.5 lvsat=-0.05040003
+ wvsat=-0.01644837 pvsat=6.302018e-08 ua=2.627049e-09 lua=-8.546864e-16 wua=-1.254542e-15
+ pua=1.185371e-21 ub=6.720354e-20 lub=1.267025e-25 wub=2.114743e-25 pub=-2.415296e-31
+ uc=-2.931487e-11 luc=-1.080733e-16 wuc=-1.11273e-16 puc=1.357534e-22 rdsw=1200
+ prwb=0 prwg=0 wr=1 u0=0.01917714 lu0=-9.664369e-09 wu0=-5.363688e-09 pu0=8.076249e-15
+ a0=0.7336237 la0=1.084121e-06 wa0=-1.509902e-08 pa0=-7.217449e-13 keta=-0.01447329
+ lketa=4.433056e-08 wketa=3.463419e-08 pketa=-5.331424e-14 a1=0 a2=-0.1695826 la2=9.275596e-07
+ wa2=4.863926e-07 pa2=-8.291167e-13 ags=1.682995e-21 lags=-3.360001e-26 wags=-2.104412e-27
+ pags=4.201345e-32 b0=0 b1=0 voff=-0.1852838 lvoff=4.752185e-08 wvoff=-4.54918e-08
+ pvoff=1.421695e-15 nfactor=1.238119 lnfactor=1.910709e-06 wnfactor=-2.077819e-07
+ pnfactor=-1.605295e-12 cit=0.0006043693 lcit=-2.770646e-09 wcit=9.012352e-10 pcit=1.563386e-15
+ cdsc=0 cdscb=0 cdscd=0 eta0=1.138794e-05 leta0=1.86711e-09 weta0=9.285205e-11
+ peta0=9.068177e-17 etab=3.373461e-21 letab=-4.940434e-27 wetab=-2.868791e-27 petab=4.201345e-33
+ dsub=0 pclm=2.181893 lpclm=1.678933e-06 wpclm=5.7873e-07 ppclm=-8.254174e-13 pdiblc1=1.025245e-05
+ lpdiblc1=-5.040004e-12 wpdiblc1=-3.156616e-13 ppdiblc1=6.30202e-18 pdiblc2=5.08415e-05
+ lpdiblc2=-1.680001e-11 wpdiblc2=-1.052205e-12 ppdiblc2=2.100673e-17 pdiblcb=0.1665117
+ lpdiblcb=-1.548601e-10 wpdiblcb=-9.699071e-12 ppdiblcb=1.93637e-16 drout=0 pscbe1=1.998263e+08
+ lpscbe1=439.6042 wpscbe1=169.0837 ppscbe1=-0.000247623 pscbe2=-2.13955e-06 lpscbe2=1.023678e-11
+ wpscbe2=5.248001e-12 ppscbe2=-9.242961e-18 pvag=0 delta=-0.003594867 ldelta=6.404751e-09
+ wdelta=1.126908e-08 pdelta=3.830013e-16 alpha0=1.5e-06 beta0=38.1 kt1=-0.4606366
+ lkt1=2.002754e-07 wkt1=-8.26919e-08 pkt1=-2.912742e-13 kt2=-0.144904 lkt2=3.022708e-08
+ wkt2=1.044265e-07 pkt2=-3.067791e-14 at=6797.024 lat=-0.006456166 wat=-0.003306198
+ pat=5.503763e-09 ute=-0.6266242 lute=-3.507708e-07 wute=-4.961028e-07 pute=2.982954e-13
+ ua1=4.228125e-09 lua1=-3.30007e-15 wua1=-2.76718e-15 pua1=1.937947e-21 ub1=-6.399666e-18
+ lub1=2.677785e-24 wub1=3.102192e-24 pub1=-1.549702e-30 uc1=-1.781346e-10 luc1=2.693236e-16
+ wuc1=1.148277e-16 puc1=-2.560835e-22 kt1l=0 prt=0 js=0.0001 jsw=2.42572e-11 pb=1.236234
+ mj=0.6625574 mjsw=0.4851755 pbsw=1.236234 pbswg=1.236234 cj=cjp5 cjsw=cjswp5 cjswg=cjswgp5
+ cgdo=cgop5 cgso=cgop5 cta=1.377674e-3 ctp=4.878735e-4 pta=2.163191e-3 ptp=2.163191e-3
+ mjswg=0.4851755 xti=3 n=1 capmod=0 nqsmod=0 xpart=1 cf=0
+
//
//
     5: type=p minr=1e-60 lmin=8.145e-07 - dxl5 lmax=1.5145e-06 - dxl5 wmin=7.804e-07 - dxw5
+ wmax=1.1804e-06 - dxw5 tnom=25 version=3.1 tlev=1 tlevc=1 ldif=1.2e-07
+ hdif=hdifp5 rsh=153 rd=0 rs=0 tox=toxp5 xj=1e-07 nch=4.3968e+16 lln=1 lwn=1 wln=1
+ wwn=1 lint=4e-08 ll=0 lw=0 lwl=0 wint=4e-08 wl=0 ww=0 wwl=0 mobmod=1 binunit=2
+ xl=3e-08 + dxl5 xw=1.5e-07 + dxw5 dwg=0 dwb=0 vth0=dvtp5 - 1.046213 lvth0=-6.647712e-08
+ wvth0=-5.0101e-08 pvth0=6.73034e-14 k1=-0.9877297 lk1=1.444324e-06 wk1=1.503539e-06
+ pk1=-1.349815e-12 k2=0.4822159 lk2=-4.332972e-07 wk2=-4.201993e-07 pk2=4.056186e-13
+ k3=0 dvt0=0 dvt1=0 dvt2=0 dvt0w=0 dvt1w=0 dvt2w=0 nlx=0 w0=0 k3b=0 vsat=113450.8
+ lvsat=0.05900348 wvsat=0.07013301 pvsat=-6.377823e-08 ua=8.304542e-10 lua=1.776426e-15
+ wua=4.583419e-16 pua=-1.323147e-21 ub=-7.170376e-19 lub=1.275224e-24 wub=8.943859e-25
+ pub=-1.241654e-30 uc=-2.1953e-10 luc=1.704967e-16 wuc=5.969175e-17 puc=-1.146245e-22
+ rdsw=1200 prwb=0 prwg=0 wr=1 u0=0.01147307 lu0=1.61824e-09 wu0=2.134126e-09 pu0=-2.904299e-15
+ a0=2.936364 la0=-2.141791e-06 wa0=-1.980067e-06 pa0=2.15595e-12 keta=0.03570177
+ lketa=-2.915083e-08 wketa=-1.473604e-08 pketa=1.898848e-14 a1=0 a2=0.533437 la2=-1.020125e-07
+ wa2=-1.668495e-07 pa2=1.275565e-13 ags=0.03549903 lags=-5.198832e-08 wags=-1.16132e-08
+ pags=1.700753e-14 b0=0 b1=0 voff=-0.09613537 lvoff=-8.303599e-08 wvoff=-8.410113e-08
+ pvoff=5.796507e-14 nfactor=-0.4545338 lnfactor=4.3896e-06 wnfactor=1.214895e-06
+ pnfactor=-3.688806e-12 cit=-0.002083016 lcit=1.16503e-09 wcit=3.138267e-09 pcit=-1.712746e-15
+ cdsc=0 cdscb=0 cdscd=0 eta0=0.003446544 leta0=-3.163676e-09 weta0=-3.31069e-09
+ peta0=5.07517e-15 etab=-0.001827905 letab=2.676968e-09 wetab=2.308161e-09 petab=-3.380302e-15
+ dsub=0 pclm=2.108815 lpclm=1.785955e-06 wpclm=1.733451e-06 ppclm=-2.516506e-12
+ pdiblc1=3.328151e-06 lpdiblc1=5.100628e-12 wpdiblc1=8.342479e-12 ppdiblc1=-6.377825e-18
+ pdiblc2=2.77605e-05 lpdiblc2=1.700209e-11 wpdiblc2=2.780826e-11 ppdiblc2=-2.125942e-17
+ pdiblcb=0.002299662 lpdiblcb=2.403336e-07 wpdiblcb=2.563326e-10 ppdiblcb=-1.959662e-16
+ drout=0 pscbe1=4.769574e+08 lpscbe1=33.74586 wpscbe1=5.794987 ppscbe1=-8.486756e-06
+ pscbe2=6.700817e-06 lpscbe2=-2.709934e-12 wpscbe2=-2.216328e-12 ppscbe2=1.68855e-18
+ pvag=0 delta=-0.009292756 ldelta=1.474931e-08 wdelta=2.412366e-08 pdelta=-1.844254e-14
+ alpha0=1.5e-06 beta0=38.1 kt1=-0.165207 lkt1=-2.323812e-07 wkt1=-4.787468e-07
+ pkt1=2.887481e-13 kt2=-0.1231909 lkt2=-1.571814e-09 wkt2=7.755077e-08 pkt2=8.681571e-15
+ at=9207.46 lat=-0.009986251 wat=-0.004492399 pat=7.240955e-09 ute=-0.5560366 lute=-4.541463e-07
+ wute=-8.440457e-07 pute=8.078578e-13 ua1=5.768875e-09 lua1=-5.556499e-15 wua1=-5.899314e-15
+ pua1=6.524959e-21 ub1=-1.098957e-17 lub1=9.3997e-24 wub1=8.353628e-24 pub1=-9.240429e-30
+ uc1=4.340329e-11 luc1=-5.511853e-17 wuc1=-8.574859e-17 puc1=3.766042e-23 kt1l=0
+ prt=0 js=0.0001 jsw=2.42572e-11 pb=1.236234 mj=0.6625574 mjsw=0.4851755 pbsw=1.236234
+ pbswg=1.236234 cj=cjp5 cjsw=cjswp5 cjswg=cjswgp5 cgdo=cgop5 cgso=cgop5 cta=1.377674e-3
+ ctp=4.878735e-4 pta=2.163191e-3 ptp=2.163191e-3 mjswg=0.4851755 xti=3 n=1 capmod=0
+ nqsmod=0 xpart=1 cf=0
//
//
     6: type=p minr=1e-60 lmin=5e-07 lmax=8.145e-07 - dxl5 wmin=7.804e-07 - dxw5 wmax=1.1804e-06
+ - dxw5 tnom=25 version=3.1 tlev=1 tlevc=1 ldif=1.2e-07 hdif=hdifp5 rsh=153
+ rd=0 rs=0 tox=toxp5 xj=1e-07 nch=4.3968e+16 lln=1 lwn=1 wln=1 wwn=1 lint=4e-08
+ ll=0 lw=0 lwl=0 wint=4e-08 wl=0 ww=0 wwl=0 mobmod=1 binunit=2 xl=3e-08 + dxl5
+ xw=1.5e-07 + dxw5 dwg=0 dwb=0 vth0=dvtp5 - 1.213369 lvth0=6.131354e-08 wvth0=6.563595e-08
+ pvth0=-2.117749e-14 k1=1.495269 lk1=-4.539285e-07 wk1=-6.873088e-07 pk1=3.250882e-13
+ k2=-0.2729335 lk2=1.440145e-07 wk2=2.775787e-07 pk2=-1.278326e-13 k3=0 dvt0=0
+ dvt1=0 dvt2=0 dvt0w=0 dvt1w=0 dvt2w=0 nlx=0 w0=0 k3b=0 vsat=99618.88 lvsat=0.06957798
+ wvsat=0.1101887 pvsat=-9.440079e-08 ua=6.490906e-09 lua=-2.550989e-15 wua=-4.226292e-15
+ pua=2.258255e-21 ub=1.549105e-19 lub=6.086194e-25 wub=-4.515895e-25 pub=-2.126554e-31
+ uc=6.630156e-11 luc=-4.802149e-17 wuc=-7.733701e-17 puc=-9.865972e-24 rdsw=1200
+ prwb=0 prwg=0 wr=1 u0=0.02423079 lu0=-8.135038e-09 wu0=-1.000738e-08 pu0=6.377885e-15
+ a0=-2.536917 la0=2.042532e-06 wa0=2.919793e-06 pa0=-1.589993e-12 keta=-0.05848336
+ lketa=4.285371e-08 wketa=5.555676e-08 pketa=-3.475036e-14 a1=0 a2=1.101813 la2=-5.365363e-07
+ wa2=-5.968221e-07 pa2=4.562705e-13 ags=-0.05186437 lags=1.4801e-08 wags=2.709746e-08
+ pags=-1.258677e-14 b0=0 b1=0 voff=0.248173 lvoff=-3.462598e-07 wvoff=-4.626586e-07
+ pvoff=3.473723e-13 nfactor=9.505318 lnfactor=-3.224707e-06 wnfactor=-7.142056e-06
+ pnfactor=2.700083e-12 cit=-0.000525524 lcit=-2.567271e-11 wcit=1.242749e-09 pcit=-2.636227e-16
+ cdsc=0 cdscb=0 cdscd=0 eta0=-0.01178137 leta0=8.478067e-09 weta0=9.890224e-09
+ peta0=-5.01693e-15 etab=0.002543567 letab=-6.650236e-10 wetab=-2.525672e-09 petab=3.15164e-16
+ dsub=0 pclm=6.942001 lpclm=-1.909015e-06 wpclm=-3.860021e-06 ppclm=1.759703e-12
+ pdiblc1=1.152208e-05 lpdiblc1=-1.163633e-12 wpdiblc1=-1.29438e-12 ppdiblc1=9.895537e-19
+ pdiblc2=0.0001028572 lpdiblc2=-4.040936e-11 wpdiblc2=-4.494981e-11 ppdiblc2=3.436412e-17
+ pdiblcb=0.3167475 lpdiblcb=-6.175458e-11 wpdiblcb=-6.86934e-11 ppdiblcb=5.25161e-17
+ drout=0 pscbe1=7.38258e+08 lpscbe1=-166.0185 wpscbe1=-156.3144 ppscbe1=0.0001154459
+ pscbe2=8.84908e-06 lpscbe2=-4.352281e-12 wpscbe2=-2.840519e-12 ppscbe2=2.165743e-18
+ pvag=0 delta=0.01 alpha0=1.5e-06 beta0=38.1 kt1=-0.5926163 lkt1=9.437314e-08 wkt1=9.192481e-09
+ pkt1=-8.42814e-14 kt2=-0.2266637 lkt2=7.753317e-08 wkt2=1.885819e-07 pkt2=-7.620172e-14
+ at=-17240.28 lat=0.01023304 wat=0.01636193 pat=-8.702179e-09 ute=-2.667988 lute=1.16044e-06
+ wute=1.648334e-06 pute=-1.097567e-12 ua1=-1.541431e-08 lua1=1.063804e-14 wua1=1.579226e-14
+ pua1=-1.005825e-20 ub1=2.266154e-17 lub1=-1.632658e-23 wub1=-2.355909e-23 pub1=1.515684e-29
+ uc1=2.79781e-10 luc1=-2.358293e-16 wuc1=-3.548269e-16 puc1=2.433708e-22 kt1l=0
+ prt=0 js=0.0001 jsw=2.42572e-11 pb=1.236234 mj=0.6625574 mjsw=0.4851755 pbsw=1.236234
+ pbswg=1.236234 cj=cjp5 cjsw=cjswp5 cjswg=cjswgp5 cgdo=cgop5 cgso=cgop5 cta=1.377674e-3
+ ctp=4.878735e-4 pta=2.163191e-3 ptp=2.163191e-3 mjswg=0.4851755 xti=3 n=1 capmod=0
+ nqsmod=0 xpart=1 cf=0
//
//
     7: type=p minr=1e-60 lmin=1.5145e-06 - dxl5 lmax=2.01e-05 wmin=4e-07 wmax=7.804e-07 -
+ dxw5 tnom=25 version=3.1 tlev=1 tlevc=1 ldif=1.2e-07 hdif=hdifp5 rsh=153
+ rd=0 rs=0 tox=toxp5 xj=1e-07 nch=4.3968e+16 lln=1 lwn=1 wln=1 wwn=1 lint=4e-08
+ ll=0 lw=0 lwl=0 wint=4e-08 wl=0 ww=0 wwl=0 mobmod=1 binunit=2 xl=3e-08 + dxl5
+ xw=1.5e-07 + dxw5 dwg=0 dwb=0 vth0=dvtp5 - 1.072314 lvth0=-3.539007e-08 wvth0=-2.169438e-08
+ pvth0=3.177143e-14 k1=0.8312609 lk1=-2.175675e-07 wk1=-1.689184e-07 pk1=2.473809e-13
+ k2=-0.1059928 lk2=1.814702e-07 wk2=1.046229e-07 pk2=-1.532202e-13 k3=0 dvt0=0
+ dvt1=0 dvt2=0 dvt0w=0 dvt1w=0 dvt2w=0 nlx=0 w0=0 k3b=0 vsat=162736.9 lvsat=0.03260433
+ wvsat=0.00516676 pvsat=-7.56672e-09 ua=1.056216e-09 lua=8.916792e-16 wua=8.129451e-17
+ pua=-2.99738e-22 ub=3.957386e-19 lub=-1.555744e-25 wub=-6.791188e-26 pub=-1.48132e-33
+ uc=-2.419266e-10 luc=2.119447e-16 wuc=6.953203e-17 puc=-1.363899e-22 rdsw=1200
+ prwb=0 prwg=0 wr=1 u0=0.01261288 lu0=2.090131e-10 wu0=2.185545e-10 pu0=-3.200731e-16
+ a0=0.2478382 la0=9.208392e-07 wa0=3.98013e-07 pa0=-5.828901e-13 keta=0.03941834
+ lketa=-3.764223e-08 wketa=-1.119524e-08 pketa=1.639542e-14 a1=0 a2=0.4874344 la2=-1.719827e-07
+ wa2=-7.233463e-08 pa2=1.059341e-13 ags=-1.294299e-20 lags=3.36e-26 wags=1.033352e-26
+ pags=-1.513344e-32 b0=0 b1=0 voff=-0.2280561 lvoff=3.349093e-08 wvoff=-9.118196e-09
+ pvoff=1.33536e-14 nfactor=-0.2363183 lnfactor=1.824501e-06 wnfactor=1.04608e-06
+ pnfactor=-1.531984e-12 cit=0.001728264 lcit=-1.026132e-09 wcit=-5.452505e-11 pcit=7.985197e-17
+ cdsc=0 cdscb=0 cdscd=0 eta0=0.0001512361 leta0=2.615693e-09 weta0=-2.607477e-11
+ peta0=-5.459134e-16 etab=0 dsub=0 pclm=3.29804 lpclm=7.03623e-08 wpclm=-3.704412e-07
+ ppclm=5.425111e-13 pdiblc1=9.881256e-06 lpdiblc1=2.37065e-12 pdiblc2=4.960419e-05
+ lpdiblc2=7.902168e-12 pdiblcb=0.5711502 lpdiblcb=-5.92537e-07 wpdiblcb=-3.441143e-07
+ ppdiblcb=5.039554e-13 drout=0 pscbe1=4.000485e+08 lpscbe1=146.3789 wpscbe1=-1.185225
+ ppscbe1=1.735769e-06 pscbe2=4.031665e-06 lpscbe2=-6.321734e-13 pvag=0 delta=0.009656633
+ ldelta=6.855129e-09 alpha0=1.5e-06 beta0=38.1 kt1=-0.5663813 lkt1=-1.29782e-07
+ wkt1=7.233437e-09 pkt1=-1.059336e-14 kt2=-0.01846169 lkt2=-1.118631e-08 wkt2=-3.100057e-09
+ pkt2=4.540033e-15 at=3662.593 lat=-0.001087527 wat=-0.0006406783 pat=9.382732e-10
+ ute=-0.4930697 lute=-1.049945e-06 wute=-6.096776e-07 pute=8.928728e-13 ua1=4.234363e-09
+ lua1=-5.795784e-15 wua1=-2.772484e-15 pua1=4.060302e-21 ub1=-4.954291e-18 lub1=4.081095e-24
+ wub1=1.873046e-24 pub1=-2.743076e-30 uc1=-5.307838e-11 luc1=-1.720587e-17 wuc1=8.479915e-18
+ puc1=-1.241883e-23 kt1l=0 prt=0 js=0.0001 jsw=2.42572e-11 pb=1.236234 mj=0.6625574
+ mjsw=0.4851755 pbsw=1.236234 pbswg=1.236234 cj=cjp5 cjsw=cjswp5 cjswg=cjswgp5
+ cgdo=cgop5 cgso=cgop5 cta=1.377674e-3 ctp=4.878735e-4 pta=2.163191e-3 ptp=2.163191e-3
+ mjswg=0.4851755 xti=3 n=1 capmod=0 nqsmod=0 xpart=1 cf=0
+
//
//
     8: type=p minr=1e-60 lmin=8.145e-07 - dxl5 lmax=1.5145e-06 - dxl5 wmin=4e-07 wmax=7.804e-07
+ - dxw5 tnom=25 version=3.1 tlev=1 tlevc=1 ldif=1.2e-07 hdif=hdifp5 rsh=153
+ rd=0 rs=0 tox=toxp5 xj=1e-07 nch=4.3968e+16 lln=1 lwn=1 wln=1 wwn=1 lint=4e-08
+ ll=0 lw=0 lwl=0 wint=4e-08 wl=0 ww=0 wwl=0 mobmod=1 binunit=2 xl=3e-08 + dxl5
+ xw=1.5e-07 + dxw5 dwg=0 dwb=0 vth0=dvtp5 - 1.064657 lvth0=-4.66039e-08 wvth0=-3.441667e-08
+ pvth0=5.040321e-14 k1=0.7622073 lk1=-1.164385e-07 wk1=1.539287e-08 pk1=-2.254286e-14
+ k2=0.0166437 lk2=1.869144e-09 wk2=-2.427664e-08 pk2=3.555314e-14 k3=0 dvt0=0 dvt1=0
+ dvt2=0 dvt0w=0 dvt1w=0 dvt2w=0 nlx=0 w0=0 k3b=0 vsat=211262.6 lvsat=-0.03846158
+ wvsat=-0.01304613 pvsat=1.910606e-08 ua=1.285739e-09 lua=5.555428e-16 wua=7.116781e-17
+ pua=-2.849074e-22 ub=4.622625e-19 lub=-2.529987e-25 wub=-1.08491e-25 pub=5.79468e-32
+ uc=-9.712279e-11 luc=-1.204112e-19 wuc=-4.440331e-17 puc=3.046834e-23 rdsw=1200
+ prwb=0 prwg=0 wr=1 u0=0.01418713 lu0=-2.096477e-09 wu0=-1.739138e-10 pu0=2.546967e-16
+ a0=0.886176 la0=-1.400649e-08 wa0=-2.365873e-07 pa0=3.464821e-13 keta=0.03189491
+ lketa=-2.662419e-08 wketa=-1.149869e-08 pketa=1.683983e-14 a1=0 a2=0.1527727 la2=3.181293e-07
+ wa2=1.568673e-07 pa2=-2.297322e-13 ags=0.02163085 lags=-3.167838e-08 wags=1.802946e-10
+ pags=-2.640401e-16 b0=0 b1=0 voff=-0.1474396 lvoff=-8.457191e-08 wvoff=-4.047198e-08
+ pvoff=5.927121e-14 nfactor=1.188145 lnfactor=-2.616256e-07 wnfactor=-1.820393e-07
+ pnfactor=2.665965e-13 cit=0.001317423 lcit=-4.24455e-10 wcit=2.465334e-10 pcit=-3.610481e-16
+ cdsc=0 cdscb=0 cdscd=0 eta0=0.001499284 leta0=6.414783e-10 weta0=-1.65474e-09
+ peta0=1.839267e-15 etab=0.001884275 letab=-2.759521e-09 wetab=-8.486774e-10 petab=1.242888e-15
+ dsub=0 pclm=5.16654 lpclm=-2.666057e-06 wpclm=-8.668382e-07 ppclm=1.269485e-12
+ pdiblc1=1.412202e-05 lpdiblc1=-3.839946e-12 wpdiblc1=-8.366262e-13 ppdiblc1=1.225239e-18
+ pdiblc2=6.046072e-05 lpdiblc2=-7.99722e-12 pdiblcb=0.002601096 lpdiblcb=2.401032e-07
+ drout=0 pscbe1=4.304707e+08 lpscbe1=101.8257 wpscbe1=45.32733 ppscbe1=-6.638188e-05
+ pscbe2=2.437961e-06 lpscbe2=1.701805e-12 wpscbe2=1.408804e-12 ppscbe2=-2.063194e-18
+ pvag=0 delta=0.02510046 ldelta=-1.576236e-08 wdelta=-5.124331e-09 pdelta=7.504583e-15
+ alpha0=1.5e-06 beta0=38.1 kt1=-0.6983992 lkt1=6.355823e-08 wkt1=-2.532004e-08
+ pkt1=3.70812e-14 kt2=-0.03616643 lkt2=1.474229e-08 wkt2=3.5452e-09 pkt2=-5.191946e-15
+ at=2731.911 lat=0.0002754563 wat=0.001014408 pat=-1.485601e-09 ute=-1.758852 lute=8.03794e-07
+ wute=1.788287e-07 pute=-2.618947e-13 ua1=-2.61319e-09 lua1=4.232455e-15 wua1=1.228794e-15
+ pua1=-1.799569e-21 ub1=1.077108e-18 lub1=-4.75189e-24 wub1=-1.907875e-24 pub1=2.794084e-30
+ uc1=-5.846294e-11 luc1=-9.320186e-18 wuc1=8.784586e-19 puc1=-1.286503e-24 kt1l=0
+ prt=0 js=0.0001 jsw=2.42572e-11 pb=1.236234 mj=0.6625574 mjsw=0.4851755 pbsw=1.236234
+ pbswg=1.236234 cj=cjp5 cjsw=cjswp5 cjswg=cjswgp5 cgdo=cgop5 cgso=cgop5 cta=1.377674e-3
+ ctp=4.878735e-4 pta=2.163191e-3 ptp=2.163191e-3 mjswg=0.4851755 xti=3 n=1 capmod=0
+ nqsmod=0 xpart=1 cf=0
//
//
     9: type=p minr=1e-60 lmin=5e-07 lmax=8.145e-07 - dxl5 wmin=4e-07 wmax=7.804e-07 - dxw5
+ tnom=25 version=3.1 tlev=1 tlevc=1 ldif=1.2e-07 hdif=hdifp5 rsh=153 rd=0
+ rs=0 tox=toxp5 xj=1e-07 nch=4.3968e+16 lln=1 lwn=1 wln=1 wwn=1 lint=4e-08 ll=0
+ lw=0 lwl=0 wint=4e-08 wl=0 ww=0 wwl=0 mobmod=1 binunit=2 xl=3e-08 + dxl5 xw=1.5e-07
+ + dxw5 dwg=0 dwb=0 vth0=dvtp5 - 1.279173 lvth0=1.173942e-07 wvth0=1.21596e-07
+ pvth0=-6.886849e-14 k1=0.8093314 lk1=-1.524649e-07 wk1=-1.039876e-07 pk1=6.872352e-14
+ k2=0.00210548 lk2=1.298362e-08 wk2=4.368557e-08 pk2=-1.640397e-14 k3=0 dvt0=0
+ dvt1=0 dvt2=0 dvt0w=0 dvt1w=0 dvt2w=0 nlx=0 w0=0 k3b=0 vsat=275336.5 lvsat=-0.08744607
+ wvsat=-0.03924157 pvsat=3.913247e-08 ua=8.475663e-10 lua=8.905258e-16 wua=5.728044e-16
+ pua=-6.684087e-22 ub=-8.811088e-19 lub=7.740087e-25 wub=4.294413e-25 pub=-3.533025e-31
+ uc=5.17434e-11 luc=-1.139286e-16 wuc=-6.495675e-17 puc=4.618146e-23 rdsw=1200
+ prwb=0 prwg=0 wr=1 u0=0.009428292 lu0=1.541656e-09 wu0=2.580662e-09 pu0=-1.851177e-15
+ a0=0.3730342 la0=3.782906e-07 wa0=4.451705e-07 pa0=-1.747218e-13 keta=-0.008465134
+ lketa=4.231071e-09 wketa=1.302126e-08 pketa=-1.905674e-15 a1=0 a2=0.5689 wa2=-1.436326e-07
+ ags=-0.01980588 wags=-1.650825e-10 b0=0 b1=0 voff=-0.4310946 lvoff=1.322824e-07
+ wvoff=1.149906e-07 pvoff=-5.957997e-14 nfactor=0.9839504 lnfactor=-1.055187e-07
+ wnfactor=1.045151e-07 pnfactor=4.752564e-14 cit=0.001695685 lcit=-7.136368e-10
+ wcit=-6.461679e-10 pcit=3.21422e-16 cdsc=0 cdscb=0 cdscd=0 eta0=-0.006575817 leta0=6.814894e-09
+ weta0=5.463419e-09 peta0=-3.602567e-15 etab=-0.0009065561 letab=-6.259301e-10
+ wetab=4.083129e-10 petab=2.819189e-16 dsub=0 pclm=1.178333 lpclm=3.829284e-07
+ wpclm=1.041403e-06 ppclm=-1.893662e-13 pdiblc1=7.70446e-06 lpdiblc1=1.066278e-12
+ wpdiblc1=1.952127e-12 ppdiblc1=-9.067632e-19 pdiblc2=5e-05 pdiblcb=0.3166667 drout=0
+ pscbe1=6.129551e+08 lpscbe1=-37.68366 wpscbe1=-49.7568 ppscbe1=6.309942e-06 pscbe2=9.82452e-06
+ lpscbe2=-3.945219e-12 wpscbe2=-3.670033e-12 ppscbe2=1.819578e-18 pvag=0 delta=0.0044826
+ wdelta=4.691997e-09 alpha0=1.5e-06 beta0=38.1 kt1=-0.6020952 lkt1=-1.006621e-08
+ wkt1=1.725337e-08 pkt1=4.533822e-15 kt2=0.01669304 lkt2=-2.566878e-08 wkt2=-1.836868e-08
+ pkt2=1.156122e-14 at=3092.22 wat=-0.0009288238 ute=-0.3453608 lute=-2.768203e-07
+ wute=-3.268279e-07 pute=1.246799e-13 ua1=6.231264e-09 lua1=-2.529131e-15 wua1=-2.615141e-15
+ pua1=1.13912e-21 ub1=-9.300517e-18 lub1=3.181805e-24 wub1=3.621449e-24 pub1=-1.433085e-30
+ uc1=-2.106855e-10 luc1=1.070539e-16 wuc1=6.226576e-17 puc1=-4.821709e-23 kt1l=0
+ prt=0 js=0.0001 jsw=2.42572e-11 pb=1.236234 mj=0.6625574 mjsw=0.4851755 pbsw=1.236234
+ pbswg=1.236234 cj=cjp5 cjsw=cjswp5 cjswg=cjswgp5 cgdo=cgop5 cgso=cgop5 cta=1.377674e-3
+ ctp=4.878735e-4 pta=2.163191e-3 ptp=2.163191e-3 mjswg=0.4851755 xti=3 n=1 capmod=0
+ nqsmod=0 xpart=1 cf=0
//
//
     10: type=p minr=1e-60 lmin=1.5145e-06 - dxl5 lmax=2.01e-05 wmin=1.99804e-05 - dxw5 wmax=0.0002001
+ tnom=25 version=3.1 tlev=1 tlevc=1 ldif=1.2e-07 hdif=hdifp5 rsh=153 rd=0
+ rs=0 tox=toxp5 xj=1e-07 nch=4.3968e+16 lln=1 lwn=1 wln=1 wwn=1 lint=4e-08 ll=0
+ lw=0 lwl=0 wint=4e-08 wl=0 ww=0 wwl=0 mobmod=1 binunit=2 xl=3e-08 + dxl5 xw=1.5e-07
+ + dxw5 dwg=0 dwb=0 vth0=dvtp5 - 1.017056 lvth0=-6.93358e-08 wvth0=-1.104035e-07
+ pvth0=1.61686e-13 k1=0.5516948 lk1=-1.147104e-08 wk1=7.922754e-07 pk1=-1.160287e-12
+ k2=0.03024255 lk2=2.570502e-09 wk2=-1.249129e-07 pk2=1.82935e-13 k3=0 dvt0=0 dvt1=0
+ dvt2=0 dvt0w=0 dvt1w=0 dvt2w=0 nlx=0 w0=0 k3b=0 vsat=175000 ua=3.01673e-09 lua=-1.111881e-15
+ wua=-1.814943e-15 pua=9.247595e-21 ub=2.843372e-19 lub=7.816373e-25 wub=-1.158536e-24
+ pub=1.696676e-30 uc=-7.099344e-11 luc=3.197208e-18 wuc=8.993659e-17 puc=-1.317121e-22
+ rdsw=1200 prwb=0 prwg=0 wr=1 u0=0.02334674 lu0=-6.608755e-09 wu0=-2.195811e-08
+ pu0=3.215765e-14 a0=0.6838011 la0=8.154373e-09 wa0=1.363274e-07 pa0=-1.996514e-13
+ keta=0.00635177 lketa=-3.996862e-09 wketa=5.10849e-08 pketa=-7.481383e-14 a1=0
+ a2=0.4 ags=0.02 b0=0 b1=0 voff=-0.1618556 lvoff=2.562302e-08 wvoff=1.336677e-07
+ pvoff=-1.957564e-13 nfactor=1.28945 lnfactor=1.545114e-08 wnfactor=2.369927e-05
+ pnfactor=-3.470758e-11 cit=-0.0004092128 lcit=9.684422e-11 wcit=1.738844e-09 pcit=-2.546537e-15
+ cdsc=0 cdscb=0 cdscd=0 eta0=0.0002551735 leta0=1.631116e-09 weta0=9.144435e-10
+ peta0=-5.772949e-15 etab=0 dsub=0 pclm=2.631364 lpclm=1.08172e-06 wpclm=1.812601e-06
+ ppclm=-3.742228e-12 pdiblc1=1e-05 pdiblc2=5e-05 pdiblcb=0.1546167 lpdiblcb=2.373222e-07
+ drout=0 pscbe1=3.929429e+08 lpscbe1=156.7851 wpscbe1=29.55479 ppscbe1=-4.328278e-05
+ pscbe2=4e-06 pvag=0 delta=0.01 alpha0=1.5e-06 beta0=38.1 kt1=-0.5766668 lkt1=-2.308303e-08
+ wkt1=6.525825e-07 pkt1=-9.55707e-13 kt2=-0.03111435 lkt2=-1.73639e-09 wkt2=-5.610196e-07
+ pkt2=8.216132e-13 at=2422.758 lat=-0.003255229 wat=0.04393074 pat=-6.433656e-08
+ ute=-1.866381 lute=2.583099e-07 wute=9.378672e-06 pute=-1.373506e-11 ua1=-1.206329e-09
+ lua1=-9.324564e-17 wua1=1.430247e-14 pua1=-2.094597e-20 ub1=-4.140797e-18 lub1=2.331944e-24
+ wub1=5.656061e-23 pub1=-8.283301e-29 uc1=-7.951766e-11 luc1=2.565148e-17 wuc1=5.265044e-16
+ puc1=-7.710656e-22 kt1l=0 prt=0 js=0.0001 jsw=2.42572e-11 pb=1.236234 mj=0.6625574
+ mjsw=0.4851755 pbsw=1.236234 pbswg=1.236234 cj=cjp5 cjsw=cjswp5 cjswg=cjswgp5
+ cgdo=cgop5 cgso=cgop5 cta=1.377674e-3 ctp=4.878735e-4 pta=2.163191e-3 ptp=2.163191e-3
+ mjswg=0.4851755 xti=3 n=1 capmod=0 nqsmod=0 xpart=1 cf=0
+
//
//
     11: type=p minr=1e-60 lmin=8.145e-07 - dxl5 lmax=1.5145e-06 - dxl5 wmin=1.99804e-05 -
+ dxw5 wmax=0.0002001 tnom=25 version=3.1 tlev=1 tlevc=1 ldif=1.2e-07 hdif=hdifp5
+ rsh=153 rd=0 rs=0 tox=toxp5 xj=1e-07 nch=4.3968e+16 lln=1 lwn=1 wln=1 wwn=1 lint=4e-08
+ ll=0 lw=0 lwl=0 wint=4e-08 wl=0 ww=0 wwl=0 mobmod=1 binunit=2 xl=3e-08 + dxl5
+ xw=1.5e-07 + dxw5 dwg=0 dwb=0 vth0=dvtp5 - 1.078646 lvth0=2.086317e-08 wvth0=2.433973e-07
+ pvth0=-3.564553e-13 k1=0.5898317 lk1=-6.732257e-08 wk1=-8.803282e-07 pk1=1.289241e-12
+ k2=0.02005356 lk2=1.749228e-08 wk2=2.347025e-07 pk2=-3.437219e-13 k3=0 dvt0=0
+ dvt1=0 dvt2=0 dvt0w=0 dvt1w=0 dvt2w=0 nlx=0 w0=0 k3b=0 vsat=181677.3 lvsat=-0.009778858
+ wvsat=-0.2433714 pvsat=3.564174e-07 ua=9.757481e-10 lua=1.877137e-15 wua=3.52661e-14
+ pua=-4.50576e-20 ub=7.971141e-19 lub=3.067552e-26 wub=-5.311529e-24 pub=7.778732e-30
+ uc=-4.29688e-11 luc=-3.784487e-17 wuc=-7.497421e-16 puc=1.097997e-21 rdsw=1200
+ prwb=0 prwg=0 wr=1 u0=0.01630683 lu0=3.701184e-09 wu0=1.041825e-07 pu0=-1.525752e-13
+ a0=0.1661233 la0=7.662933e-07 wa0=4.587941e-06 pa0=-6.719039e-12 keta=0.0009181837
+ lketa=3.960625e-09 wketa=3.339665e-08 pketa=-4.890939e-14 a1=0 a2=0.4 ags=0.06368572
+ lags=-6.397773e-08 b0=0 b1=0 voff=-0.1481659 lvoff=5.574528e-09 nfactor=1.3 cit=-0.0003885595
+ lcit=6.659745e-11 cdsc=0 cdscb=0 cdscd=0 eta0=-0.0002827152 leta0=2.418854e-09
+ weta0=-1.690397e-09 peta0=-1.958161e-15 etab=0.0005078459 letab=-7.437402e-10
+ dsub=0 pclm=3.717283 lpclm=-5.086092e-07 wpclm=-1.55382e-06 ppclm=1.187895e-12
+ pdiblc1=1e-05 pdiblc2=5e-05 pdiblcb=0.3703603 lpdiblcb=-7.863436e-08 drout=0 pscbe1=4.808788e+08
+ lpscbe1=28.00306 pscbe2=5.081222e-06 lpscbe2=-1.583449e-12 pvag=0 delta=0.01 alpha0=1.5e-06
+ beta0=38.1 kt1=-0.6123038 lkt1=2.910735e-08 wkt1=-6.620191e-07 pkt1=9.69527e-13
+ kt2=-0.05207413 lkt2=2.895922e-08 wkt2=3.115155e-07 pkt2=-4.562143e-13 at=-1765.858
+ lat=0.002878998 ute=-1.897773 lute=3.042837e-07 wute=1.844754e-06 pute=-2.701642e-12
+ ua1=-1.674093e-09 lua1=5.91794e-16 ub1=-2.437612e-18 lub1=-1.623707e-25 uc1=-8.643698e-11
+ luc1=3.578483e-17 wuc1=1.162147e-15 puc1=-1.701965e-21 kt1l=0 prt=0 js=0.0001
+ jsw=2.42572e-11 pb=1.236234 mj=0.6625574 mjsw=0.4851755 pbsw=1.236234 pbswg=1.236234
+ cj=cjp5 cjsw=cjswp5 cjswg=cjswgp5 cgdo=cgop5 cgso=cgop5 cta=1.377674e-3 ctp=4.878735e-4
+ pta=2.163191e-3 ptp=2.163191e-3 mjswg=0.4851755 xti=3 n=1 capmod=0 nqsmod=0 xpart=1
+ cf=0
//
//
     12: type=p minr=1e-60 lmin=5e-07 lmax=8.145e-07 - dxl5 wmin=1.99804e-05 - dxw5 wmax=0.0002001
+ tnom=25 version=3.1 tlev=1 tlevc=1 ldif=1.2e-07 hdif=hdifp5 rsh=153 rd=0
+ rs=0 tox=toxp5 xj=1e-07 nch=4.3968e+16 lln=1 lwn=1 wln=1 wwn=1 lint=4e-08 ll=0
+ lw=0 lwl=0 wint=4e-08 wl=0 ww=0 wwl=0 mobmod=1 binunit=2 xl=3e-08 + dxl5 xw=1.5e-07
+ + dxw5 dwg=0 dwb=0 vth0=dvtp5 - 1.058984 lvth0=5.831877e-09 wvth0=-7.380264e-07
+ pvth0=3.938431e-13 k1=0.3834936 lk1=9.042292e-08 wk1=2.213848e-06 pk1=-1.076257e-12
+ k2=0.07294988 lk2=-2.294696e-08 wk2=-6.103756e-07 pk2=3.023404e-13 k3=0 dvt0=0
+ dvt1=0 dvt2=0 dvt0w=0 dvt1w=0 dvt2w=0 nlx=0 w0=0 k3b=0 vsat=168886.1 wvsat=0.2228384
+ ua=5.177781e-09 lua=-1.335317e-15 wua=-6.174405e-14 pua=2.910667e-20 ub=-3.771157e-19
+ lub=9.283744e-25 wub=2.446966e-23 pub=-1.498899e-29 uc=-1.931642e-10 luc=7.69795e-17
+ wuc=2.633014e-15 puc=-1.48812e-21 rdsw=1200 prwb=0 prwg=0 wr=1 u0=0.02853129 lu0=-5.644418e-09
+ wu0=-2.079686e-07 pu0=8.606428e-14 a0=1.053803 la0=8.766222e-08 wa0=-1.356203e-05
+ pa0=7.156612e-12 keta=0.01138427 lketa=-4.040701e-09 wketa=-3.991359e-08 pketa=7.136286e-15
+ a1=0 a2=0.5625945 la2=-1.243035e-07 wa2=-1.552626e-06 pa2=1.186983e-12 ags=-0.08883215
+ lags=5.262219e-08 wags=1.380112e-06 pags=-1.055096e-12 b0=0 b1=0 voff=-0.109096
+ lvoff=-2.429444e-08 wvoff=-3.377276e-07 pvoff=2.581928e-13 nfactor=0.8800734 lnfactor=3.210339e-07
+ wnfactor=1.77331e-05 pnfactor=-1.355696e-11 cit=-0.0007432703 lcit=3.377738e-10
+ wcit=7.590893e-09 pcit=-5.803238e-15 cdsc=0 cdscb=0 cdscd=0 eta0=-0.004140343
+ leta0=5.36801e-09 weta0=4.017752e-08 peta0=-3.396618e-14 etab=-0.0003047791 letab=-1.224885e-10
+ wetab=7.285613e-09 petab=-5.569851e-15 dsub=0 pclm=4.095334 lpclm=-7.976283e-07
+ wpclm=-6.084229e-06 ppclm=4.651393e-12 pdiblc1=1e-05 pdiblc2=5e-05 pdiblcb=0.40135
+ lpdiblcb=-1.023259e-07 wpdiblcb=-1.466066e-06 ppdiblcb=1.120808e-12 drout=0 pscbe1=5.27386e+08
+ lpscbe1=-7.55169 wpscbe1=3085.168 ppscbe1=-0.002358611 pscbe2=3.245906e-06 lpscbe2=-1.803504e-13
+ wpscbe2=6.996353e-11 ppscbe2=-5.348713e-17 pvag=0 delta=0.01 alpha0=1.5e-06 beta0=38.1
+ kt1=-0.5319197 lkt1=-3.234629e-08 wkt1=1.682085e-06 pkt1=-8.225407e-13 kt2=-0.00190553
+ lkt2=-9.394682e-09 wkt2=-4.266947e-07 pkt2=1.081473e-13 at=2063.814 lat=-4.878597e-05
+ wat=-0.01276604 pat=9.759638e-09 ute=-0.602981 lute=-6.85585e-07 wute=-6.156065e-06
+ pute=3.414984e-12 ua1=3.67648e-09 lua1=-3.498719e-15 wua1=-2.34619e-14 pua1=1.793663e-20
+ ub1=-6.626459e-18 lub1=3.040003e-24 wub1=5.427292e-23 pub1=-4.149165e-29 uc1=-1.160362e-10
+ luc1=5.841346e-17 wuc1=-3.330525e-16 puc1=-5.588843e-22 kt1l=0 prt=0 js=0.0001
+ jsw=2.42572e-11 pb=1.236234 mj=0.6625574 mjsw=0.4851755 pbsw=1.236234 pbswg=1.236234
+ cj=cjp5 cjsw=cjswp5 cjswg=cjswgp5 cgdo=cgop5 cgso=cgop5 cta=1.377674e-3 ctp=4.878735e-4
+ pta=2.163191e-3 ptp=2.163191e-3 mjswg=0.4851755 xti=3 n=1 capmod=0 nqsmod=0 xpart=1
+ cf=0
//
//  *************************************************************
//                                                              *
//                                                              *
//                 MODEL OF 5V NMOS WITH ESD IMPLANT            *
//                                                              *
//                                                              *
//                                                              *
//  *************************************************************
//
//
//   NOTE : The parameter HDIF listed in model card is based on
//          the layout of testkey PCM38, users must change this
//          value according to their layout.
//
//
//
     }
model esd5v bsim3v3 type=n minr=1e-60 version=3.1 lmin=8e-7
+ lmax=2e-6 wmin=2e-5 wmax=2e-4 xl=0.04e-6 + dxl5 xw=0.15e-6 + dxw5 tnom=25 tox=toxe5
+ xj=1.5e-7 nch=9.93e16 lln=1 lwn=1 wln=1 wwn=1 lint=9e-8 wint=1.59e-7 mobmod=1
+ binunit=2 dwg=0 dwb=0 vth0=dvte5 + 0.8159639 lvth0=6.293703e-8 wvth0=-1.608717e-7
+ pvth0=-4.8126e-14 k1=0.6559668 lk1=1.953296e-7 wk1=6.694726e-6 pk1=-4.50552e-12
+ k2=0.1558551 lk2=-7.9795e-8 wk2=-2.496228e-6 pk2=1.710858e-12 k3=0 dvt0=0 dvt1=0
+ dvt2=0 dvt0w=0 dvt1w=0 dvt2w=0 nlx=0 w0=0 k3b=0 vsat=9.298953e4 lvsat=6.570042e-4
+ wvsat=0.2017716 pvsat=-1.311919e-7 ua=5.820969e-11 lua=-3.43084e-17 wua=1.003585e-15
+ pua=5.562979e-22 ub=1.636926e-18 lub=1.283712e-24 wub=8.369159e-24 pub=-3.11540e-29
+ uc=4.338862e-11 luc=1.092981e-16 wuc=3.272107e-16 puc=-1.63804e-21 rdsw=600 prwb=0
+ prwg=2.209416e-4 lprwg=-4.456998e-9 wprwg=-2.261326e-8 pprwg=8.921047e-14 wr=1
+ u0=0.0469517 lu0=4.654215e-9 wu0=4.699849e-8 pu0=-8.43616e-14 a0=0.9105611 la0=-4.040427e-7
+ wa0=-1.767308e-6 pa0=6.165831e-12 keta=0.0106754 lketa=-2.127105e-8 wketa=-4.047217e-8
+ pketa=3.60139e-13 a1=0 a2=0.6802866 la2=-1.404497e-8 wa2=7.434166e-6 pa2=-3.66631e-12
+ ags=-2.982669e-3 lags=2.518517e-9 wags=7.952672e-7 pags=-5.02902e-13 b0=0 b1=0
+ voff=-0.1512265 lvoff=4.879334e-8 wvoff=2.321717e-7 pvoff=-3.96756e-13 nfactor=1.3083477
+ lnfactor=1.40429e-7 wnfactor=-9.527986e-6 pnfactor=4.588299e-12 cit=0 cdsc=0 cdscb=0
+ cdscd=0 eta0=1.014412e-4 leta0=2.766839e-10 weta0=2.919315e-9 peta0=-5.40073e-15
+ etab=3.301877e-4 letab=-6.10847e-10 wetab=-1.005096e-9 petab=1.859427e-15 dsub=0
+ pclm=-0.0489277 lpclm=1.427501e-6 wpclm=4.019428e-6 ppclm=2.650954e-12 pdiblc1=1e-20
+ pdiblc2=6.009903e-3 lpdiblc2=-1.868321e-9 wpdiblc2=-1.985672e-8 ppdiblc2=3.673493e-14
+ pdiblcb=0.0810399 lpdiblcb=-1.528295e-7 wpdiblcb=-1.590742e-6 ppdiblcb=2.991128e-12
+ drout=0 pscbe1=3.482836e8 lpscbe1=75.22749 wpscbe1=-144.78651 ppscbe1=5.094653e-5
+ pscbe2=2.575667e-5 lpscbe2=9.709635e-12 wpscbe2=-1.43485e-10 ppscbe2=4.190929e-17
+ pvag=2.5531826 lpvag=-1.006329e-6 wpvag=-3.303764e-5 ppvag=2.077205e-11 delta=5.085994e-3
+ ldelta=9.697086e-9 wdelta=-1.008858e-7 pdelta=6.559593e-14 alpha0=0 beta0=30 kt1=-0.43231
+ lkt1=-4.610828e-8 wkt1=5.964351e-7 pkt1=1.199277e-12 kt2=-0.0815339 lkt2=1.369035e-8
+ wkt2=8.905433e-7 pkt2=-2.31305e-13 at=2.51473e4 lat=0.0113141 wat=-0.9968733 pat=3.432854e-7
+ ute=-1.3714316 lute=-1.901169e-7 wute=-2.760377e-6 pute=4.168139e-12 ua1=1.792468e-9
+ lua1=5.269493e-16 wua1=8.13958e-15 pua1=-2.51451e-20 ub1=-1.35202e-18 lub1=-2.77189e-24
+ wub1=-5.79771e-23 pub1=1.145451e-28 uc1=4.821126e-11 luc1=-8.75312e-17 wuc1=-3.69397e-15
+ puc1=5.038823e-21 kt1l=0 prt=0 cj=cje5 mj=0.4886561 pb=0.8351256 cjsw=cjswe5 mjsw=0.3702774
+ pbsw=0.8351256 cjswg=cjswge5 mjswg=0.3702774 pbswg=0.8351256 hdif=hdife5 ldif=1.2e-7
+ rs=0 rd=0 rsh=35.9 cta=9.368412e-4 ctp=5.837846e-4 pta=1.143614e-3 ptp=1.143614e-3
+ n=1 xti=3 cgdo=cgoe5 cgso=cgoe5 capmod=0 nqsmod=0 xpart=1 cf=0 tlev=1 tlevc=1
+ js=1.050984e-6 jsw=4.265319e-11 cgbo=1e-13 rsc=0 rdc=0
endsection mos_5v
//  ****************************************************************************
//
section bip
//  *****************************************************************
//           MODEL OF P+/NW/PSUB PNP 10X10 VERTICAL BIPOLAR         *
//  *****************************************************************
model pnp10 bjt type=pnp rbmod=spice minr=1e-60 bf=6.35 nf=1.01 ise=2.95e-17 ne=1.9 is=2.95e-17
+ rb=71 irb=9.5e-4 rbm=0.1 re=2.35 ikf=1.95e-3 nkf=0.549 vaf=300 br=0.01116 nr=1
+ isc=2.95e-17 nc=1.1 rc=21.08 ikr=0.087818 var=7.8 tbf1=6.7e-3 tbf2=8e-6 tne1=9e-5
+ tnf1=9.5e-5 trb1=3e-5 tirb1=9e-4 trm1=9.44068e-6 tre1=5e-4 tikf1=-3.5e-3 tvaf1=-9e-4
+ tbr1=-7e-4 tbr2=9.5e-6 tnr1=9e-5 tnc1=1.50731e-3 xtb=0 xti=3 trc1=0 tikr1=-3.9e-3
+ eg=1.18 cje=1.55101e-13 vje=1.23623 mje=0.662557 fc=0.5 cjc=3.131405e-14 vjc=0.552774
+ mjc=0.32993 tlevc=1 cte=4.87874e-4 ctc=2.63294e-3 tvje=2.16319e-3 tvjc=2.955e-3
+ tnom=25 tlev=0
//  ****************************************************************
//            MODEL OF P+/NW/PSUB PNP 5X5 VERTICAL BIPOLAR         *
//  ****************************************************************
model pnp5 bjt type=pnp rbmod=spice minr=1e-60 bf=7.55 nf=1.034 ise=1.55e-17 ne=1.45 is=1.55e-17
+ rb=140 irb=1.95e-3 rbm=0.1 re=0.05 ikf=7.755e-4 nkf=0.515 vaf=290 br=4.15e-3 nr=1.0355
+ isc=1.55e-17 nc=1.4 rc=21.08 ikr=1e-4 var=6.8 tbf1=6.75e-3 tbf2=1e-5 tne1=9e-6
+ tnf1=2.46e-4 trb1=9e-5 tirb1=9e-5 trm1=9.44068e-6 tre1=-1e-4 tikf1=-3.15e-3 tvaf1=5.3e-5
+ tbr1=-4e-4 tbr2=8e-6 tnr1=1.961e-4 tnc1=-4.507315e-4 xtb=0 xti=3 trc1=1e-3 tikr1=-1e-5
+ eg=1.18 cje=4.292525e-14 vje=1.23623 mje=0.662557 fc=0.5 cjc=1.31504e-14 vjc=0.552774
+ mjc=0.32993 tlevc=1 cte=4.87874e-4 ctc=2.63294e-3 tvje=2.16319e-3 tvjc=2.955e-3
+ tnom=25 tlev=0
//
//
endsection bip
//
//
//  ****************************************************************
//            DIODE MODEL  ( N+/PW, P+/NW, NW/PW )                 *
//  ****************************************************************
section dio
//
//
inline subckt ndio (1 2)
parameters area=1e-13 pj=0 rs=2.03e-7
  r1 (1 3) resistor r=rs/area tc1=2.9912e-3
  diode (3 2) xdio area=area pj=pj
ends ndio
model xdio diode level=1 is=2.82e-6 n=1.25 bv=8.3 ibv=0.03
+ ns=1.25 nz=1.25 imax=1e40 minr=1e-10 allow_scaling=1
+ isw=1.36e-11   cj=1.416829e-3 vj=0.9191281 mj=0.5464087
+ cjsw=4.173308e-10 vjsw=0.9191281 mjsw=0.3948903 tlev=1 eg=1.17 xti=3 tbv1=-8e-4
+ tlevc=1 cta=9.472773e-4 ctp=6.252666e-4 pta=1.27702e-3 ptp =1.27702e-3
+ tnom=25 fc=0
//
//
//
inline subckt pdio (1 2)
parameters area=1e-13 pj=0 rs=1.7e-7
  r1 (1 3) resistor r=rs/area tc1=2.912e-3
  diode (3 2) ydio area=area pj=pj
ends pdio
model ydio diode level=1 is=2.65e-6 n=1.23 bv=9 ibv=0.03
+ ns=1.23 nz=1.23 imax=1e40 minr=1e-10 allow_scaling=1
+ isw=1.05e-11   cj=1.416829e-3 vj=0.9191281 mj=0.5464087
+ cjsw=4.173308e-10 vjsw=0.9191281 mjsw=0.3948903 tlev=1 eg=1.17 xti=3 tbv1=-8e-4
+ tlevc=1 cta=9.472773e-4 ctp=6.252666e-4 pta=1.27702e-3 ptp =1.27702e-3
+ tnom=25 fc=0
//
//
model nw_dio diode level=1 is=1.2e-5 n=1.35 bv=22 ibv=0.03
+ isw=2.554e-11   cj=1.416829e-3 vj=0.9191281 mj=0.5464087
+ cjsw=4.173308e-10 vjsw=0.9191281 mjsw=0.3948903 tlev=1 eg=1.17 xti=3 tbv1=-6.5e-4
+ tlevc=1 cta=9.472773e-4 ctp=6.252666e-4 pta=1.27702e-3 ptp =1.27702e-3
+ tnom=25 fc=0
//
endsection dio
//
//
//  ****************************************************************************
//
//
section res
ahdl_include "res_va.va"
//
subckt rnod n1 n2
parameters w=1u l=1u
R1 (n1 n2) res_va w=w l=l r=80 etch=-0.059u tc1=1.51e-3 tc2=0
+vc1=9.78e-4 vc2=-4.01e-5
ends rnod

subckt rpod n1 n2
parameters w=1u l=1u
R1 (n1 n2) res_va w=w l=l r=150 etch=-0.094u tc1=1.40e-3 tc2=0
+vc1=1.03e-3 vc2=-5.76e-4
ends rpod

subckt rnwod n1 n2
parameters w=1u l=1u
R1 (n1 n2) res_va w=w l=l r=1050 etch=1.418u tc1=5.10e-3 tc2=1.29e-5
+vc1=1.498e-2 vc2=-4.33e-4
ends rnwod

subckt rpo1 n1 n2
parameters w=1u l=1u
R1 (n1 n2) res_va w=w l=l r=8 etch=0u tc1=8.67e-4 tc2=0
+vc1=3.22e-4 vc2=-3.01e-5
ends rpo1

subckt rpo2 n1 n2
parameters w=1u l=1u
R1 (n1 n2) res_va w=w l=l r=50 etch=0u tc1=1.07e-3 tc2=0
+vc1=-6.14e-6 vc2=2.33e-4
ends rpo2

subckt rm1 n1 n2
parameters w=1u l=1u
R1 (n1 n2) res_va w=w l=l r=0.083 etch=-0.02u tc1=3.27e-3 tc2=0
+vc1=0 vc2=0
ends rm1

subckt rm2 n1 n2
parameters w=1u l=1u
R1 (n1 n2) res_va w=w l=l r=0.08 etch=-0.02u tc1=3.29e-3 tc2=0
+vc1=0 vc2=0
ends rm2

subckt rm3 n1 n2
parameters w=1u l=1u
R1 (n1 n2) res_va w=w l=l r=0.08 etch=-0.02u tc1=3.34e-3 tc2=0
+vc1=0 vc2=0
ends rm3

subckt rm4 n1 n2
parameters w=1u l=1u
R1 (n1 n2) res_va w=w l=l r=0.051 etch=-0.02u tc1=3.18e-3 tc2=0
+vc1=0 vc2=0
ends rm4

//
endsection res
//
endlibrary vlsi35
